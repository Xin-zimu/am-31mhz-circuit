LM393P Stage 1 - RC oscillator, PWM threshold, amplitude potentiometer
* TI LM393 macromodel from installed NI Multisim master database LM393/TI.
* U1A: DIP pins IN+=3 IN-=2 V+=8 GND=4 OUT=1
* U1B: DIP pins IN+=5 IN-=6 V+=8 GND=4 OUT=7
V5 V5 0 5
CDEC V5 0 100n
CBULK V5 0 10u
RPU1 V5 OSC 2.2k
RHT V5 HYST 30k
RHB HYST 0 10k
RHF OSC HYST 20k
RFIX OSC FSET 22k
RVRF FSET RAMP 15288.86443
CT RAMP 0 1n
ECOMP1 OSC 0 POLY(2) (HYST,RAMP) (V5,0) 0 1 0
* VDUTY resistor chain: 10k + 10k potentiometer + 4.7k.
RDT V5 DUTY_TOP 10k
RVDT DUTY_TOP DUTY 7362.468268
RVDB DUTY DUTY_BOT 2637.531732
RDB DUTY_BOT 0 4.7k
ECOMP2 PWM_RAW 0 POLY(2) (DUTY,RAMP) (V5,0) 0 1 0
RPU2 V5 PWM_RAW 2.2k
* 20k amplitude potentiometer, wiper at V1, includes specified load.
RVAT PWM_RAW V1 1847.92782
RVAB V1 0 18152.07218
RINPUT V1 0 1000000
CINPUT V1 0 15p

VCC VCC 0 9
VREF VREF 0 4.5
VCARRIER TP2 0 SIN(0 1 31meg)
EAM TP3 0 POLY(2) (TP2,0) (V1,0) 0 0.6 0 0 0.1
EPA TP4 0 TP3 0 1
ECHANNEL ANT_RX 0 TP4 0 0.1
ERX TP5 0 ANT_RX 0 10
RRF TP5 RF_OUT 50
C110 RF_OUT DET_RF 220p
R117 DET_RF 0 1k
D101 DET_RF TP6 SCHOTTKY_EST
R110 TP6 0 10k
C111 TP6 0 47p
C115 TP6 BB_IN 10n
R113 BB_IN VREF 100k
* OPA197 non-inverting baseband amplifier, +9 V / 0 V supply.
* 10k gain resistor, 150k + 3.511k trim feedback = gain 16.3511.
EOPABOX BBO 0 POLY(2) (BB_IN,BB_FB) (VCC,0) 0 1 0
RG_BB BB_FB VREF 10k
RF_BB BBO FB_TRIM 150k
RV_BB FB_TRIM BB_FB 3.511k
CBB_DECOUPLE VCC 0 100n

RBB BBO V2_OP 1k
CBB V2_OP 0 1.32629119243e-10
R116 V2_OP V2 100
RLOAD V2 0 1meg
.model SCHOTTKY_EST D(Is=20n N=1.06 Rs=2 Cjo=2p M=0.33 Vj=0.35 Bv=70 Ibv=10u)

.tran 2n 200u 0 2n
.end
