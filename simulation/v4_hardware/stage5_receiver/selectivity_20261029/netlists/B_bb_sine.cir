* Wrapper; dependency hashes bind the source and original TI library.
* source_sha256=6215862549b2176f14a018663ebac987d1dcb0c0fcd05ae080c0b55757533a0a
* model_sha256=fc5b020e63346e511bd808bf41c856b0150b000bcf8a41fe00eeececb1f422a5
.control
set ngbehavior=ps
source D:/ms_xsp/s05_selectivity_20261029/B_bb_sine_source.cir
set filetype=binary
save v(out) v(bbin) v(ref) v(bbo) v(final) i(vsup)
tran 0.5n 400u 150u 0.5n
write D:/ms_xsp/s05_selectivity_20261029/B_bb_sine.raw
quit
.endc
.end
