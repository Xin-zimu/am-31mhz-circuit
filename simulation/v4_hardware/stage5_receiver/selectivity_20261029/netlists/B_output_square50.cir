* Wrapper; dependency hashes bind the source and original TI library.
* source_sha256=9b329f681f4074be26aaa28aa97b3ced5d8ca39b0fb8123c703f6ddd69c04fc8
* model_sha256=fc5b020e63346e511bd808bf41c856b0150b000bcf8a41fe00eeececb1f422a5
.control
set ngbehavior=ps
source D:/ms_xsp/s05_selectivity_20261029/B_output_square50_source.cir
set filetype=binary
save v(out) v(bbin) v(ref) v(bbo) v(final) i(vsup)
tran 0.5n 400u 150u 0.5n
write D:/ms_xsp/s05_selectivity_20261029/B_output_square50.raw
quit
.endc
.end
