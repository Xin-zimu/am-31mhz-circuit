* Wrapper; dependency hashes bind the source and original TI library.
* source_sha256=6318401b361636c5dd24af9d466db60179a1d100981033c66a9f4f8160d1cc8f
* model_sha256=fc5b020e63346e511bd808bf41c856b0150b000bcf8a41fe00eeececb1f422a5
.control
set ngbehavior=ps
source D:/ms_xsp/s05_selectivity_20261029/B_bb_sine_v2_source.cir
set filetype=binary
save v(out) v(bbin) v(ref) v(bbo) v(final) i(vsup)
tran 0.5n 400u 150u 0.5n
write D:/ms_xsp/s05_selectivity_20261029/B_bb_sine_v2.raw
quit
.endc
.end
