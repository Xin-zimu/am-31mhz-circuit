* Fixed wanted waveform + independent CW -> real BAT85 control
BREPLAY drive 0 V=0.167621561827946*cos(2*pi*30980000*time+0.0859295112083987)+0.680211369973958*cos(2*pi*31000000*time+-1.49357215614685)+0.167693463925682*cos(2*pi*31020000*time+-3.06810447673501)+0.601058633731322*cos(2*pi*29000000*time+-0.911843412905378)
RS drive rf 1e-06
* Actual Nexperia BAT85 manufacturer model; not BAT85S
RCONNECT rf an 0.1
XDET an det BAT85
RDET det 0 4700
CDET det 0 100p
RFILT det out 4700
CFILT out 0 100p
RLOAD out 0 100000
.SUBCKT BAT85 1 2
D1 1 2 BAT85
R1 1 2 5.416E+7
.MODEL BAT85 D
+ IS = 2.076E-7
+ N = 1.023
+ BV = 33
+ IBV = 10E-6
+ RS = 2.326
+ CJO = 1.21E-11
+ VJ = 0.1319
+ M = 0.2904
+ EG = 0.69
+ XTI = 2
.ENDS
.model 2N3904   NPN(Is=6.734f Xti=3 Eg=1.11 Vaf=74.03 Bf=416.4 Ne=1.259
+               Ise=6.734f Ikf=66.78m Xtb=1.5 Br=.7371 Nc=2 Isc=0 Ikr=0 Rc=1
+               Cjc=3.638p Mjc=.3085 Vjc=.75 Fc=.5 Cje=4.493p Mje=.2593 Vje=.75
+               Tr=239.5n Tf=301.2p Itf=.4 Vtf=4 Xtf=2 Rb=10)

.options method=trap reltol=1e-4 trtol=3 abstol=1p vntol=1u temp=27
.control
set filetype=binary
save v(rf) v(det) v(out)
tran 0.5n 200u 100u 0.5n
write D:/ms_xsp/s05_blocker_20261029/D_rs0_29_10.raw
quit
.endc
.end
