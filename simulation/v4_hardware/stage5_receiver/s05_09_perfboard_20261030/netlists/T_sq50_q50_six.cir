* S05-06. Source SHA256 bcaedb894be12d2db87005304cdede8b77724c77bc1bf8f834a7a5951d863a4f
.control
set ngbehavior=ps
source D:/ms_xsp/s05_parts_tran_20261030/T_sq50_q50_six_source.cir
set filetype=binary
set num_threads=1
save v(src) v(input) v(port) v(b1) v(c1) v(e1) v(b2) v(c2) v(e2) v(ee) v(rf) v(det) v(out) i(vsup) v(bbin) v(ref) v(bbo) v(final)
tran 0.5n 400u 100u 0.5n
write D:/ms_xsp/s05_parts_tran_20261030/T_sq50_q50_six.raw
quit
.endc
.end
