* S05-06. Source SHA256 bb44c77eb89a40513a58d6fa9ad0c708fb1cad3b0ad43274aa4db4f5db078660
.control
set ngbehavior=ps
source D:/ms_xsp/s05_parts_tran_20261030/T_sq50_q55_six_source.cir
set filetype=binary
set num_threads=1
save v(src) v(input) v(port) v(b1) v(c1) v(e1) v(b2) v(c2) v(e2) v(ee) v(rf) v(det) v(out) i(vsup) v(bbin) v(ref) v(bbo) v(final)
tran 0.5n 400u 100u 0.5n
write D:/ms_xsp/s05_parts_tran_20261030/T_sq50_q55_six.raw
quit
.endc
.end
