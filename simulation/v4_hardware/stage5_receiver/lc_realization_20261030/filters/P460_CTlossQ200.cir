* S05-07 independent loaded LC fixture; original active stages unchanged
CSEL input tank1 14.5p
CK tank1 tank2 2.4p
COUT tank2 port 10.8p
RPORT port 0 1Meg
RCT1 tank1 ct_loss1 0.627898274852
CTUNE1 ct_loss1 0 40.8826606788p
CBOARD1 tank1 0 1p
RLOSS1 tank1 ln1 1.79196444961
LSEL1 ln1 0 460n
CSELF1 tank1 0 0.476348275737p
RCT2 tank2 ct_loss2 0.553906382081
CTUNE2 ct_loss2 0 46.3438460759p
CBOARD2 tank2 0 1p
RLOSS2 tank2 ln2 1.79196444961
LSEL2 ln2 0 460n
CSELF2 tank2 0 0.476348275737p
