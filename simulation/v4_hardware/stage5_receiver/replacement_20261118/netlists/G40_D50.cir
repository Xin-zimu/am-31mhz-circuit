* S05-06. Source SHA256 c177e53a45b30b7e15e97b97ade9990d7331d4ff4433aa735817b421a288a2f5
.control
set ngbehavior=ps
source D:/ms_xsp/s05_replacement_20261118/G40_D50_source.cir
set filetype=binary
set num_threads=1
save v(src) v(input) v(port) v(b1) v(c1) v(e1) v(b2) v(c2) v(e2) v(ee) v(rf) v(det) v(out) i(vsup) v(bbin) v(ref) v(bbo) v(final)
tran 0.5n 450u 150u 0.5n
write D:/ms_xsp/s05_replacement_20261118/G40_D50.raw
quit
.endc
.end
