* S05 selection fixture; not wireless qualification
VMOD mod 0 PULSE(-1 1 0 50n 50n 2.495e-05 50u)
BSIG src 0 V=0.009604382771324882*(1+0.2644900633354551*v(mod))*sin(2*pi*31meg*time)
RSOURCE src input 50
* S05-08 purchasable-part loaded fixture; original active stages unchanged
CSEL input tank1 15p
CK tank1 tank2 2.4p
COUT tank2 port 11p
RPORT port 0 1Meg
RCT1 tank1 ctl1 0.665050507463
CTUNE1 ctl1 0 38.5988008783p
RLOSS1 tank1 ln1 3.66184039702
LSEL1 ln1 0 470n
CSELF1 tank1 0 0.739290077068p
RCT2 tank2 ctl2 0.548603135508
CTUNE2 ctl2 0 46.7918435935p
RLOSS2 tank2 ln2 3.66184039702
LSEL2 ln2 0 470n
CSELF2 tank2 0 0.739290077068p
VSUP vcc 0 9
CIN1 port b1 1n
RBT1 vcc b1 22k
RBB1 b1 0 4.7k
Q1 c1 b1 e1 2N3904
RC1 vcc c1 1000
REU1 e1 eb1 33
REB1 eb1 0 220
CEB1 eb1 0 330p
CIN2 c1 b2 100p
RBT2 vcc b2 22k
RBB2 b2 0 4.7k
Q2 c2 b2 e2 2N3904
RC2 vcc c2 1000
REU2 e2 eb2 33
REB2 eb2 0 220
CEB2 eb2 0 330p
CBUF c2 bb 100p
RBTB vcc bb 10k
RBBB bb 0 10k
QBUF vcc bb ee 2N3904
REBUF ee 0 470
COBUF ee rf 1n
RRF rf 0 1000
* Actual Nexperia BAT85 manufacturer model; not BAT85S
RCONNECT rf an 0.1
XDET an det BAT85
RDET det 0 4700
CDET det 0 100p
RFILT det out 4700
CFILT out 0 100p
RLOAD out 0 1000000000000000.0
.SUBCKT BAT85 1 2
D1 1 2 BAT85
R1 1 2 5.416E+7
.MODEL BAT85 D
+ IS = 2.076E-7
+ N = 1.023
+ BV = 33
+ IBV = 10E-6
+ RS = 2.326
+ CJO = 1.21E-11
+ VJ = 0.1319
+ M = 0.2904
+ EG = 0.69
+ XTI = 2
.ENDS
.model 2N3904   NPN(Is=6.734f Xti=3 Eg=1.11 Vaf=74.03 Bf=416.4 Ne=1.259
+               Ise=6.734f Ikf=66.78m Xtb=1.5 Br=.7371 Nc=2 Isc=0 Ikr=0 Rc=1
+               Cjc=3.638p Mjc=.3085 Vjc=.75 Fc=.5 Cje=4.493p Mje=.2593 Vje=.75
+               Tr=239.5n Tf=301.2p Itf=.4 Vtf=4 Xtf=2 Rb=10)
* Passive 3 V reference, isolated output, noninverting gain.
RVT vcc ref 20k
RVB ref 0 10k
CVREF ref 0 10u
CCOUP out bbin 100n
RBIAS bbin ref 100k
RG neg ref 10k
RFB bbo neg 430000
XOPA bbin neg vcc 0 bbo OPAx197
ROUT bbo final 100
RBBLOAD final 0 1000000.0
CLOAD final 0 100p
.ic v(out)=0.04886110391183965 v(bbin)=3 v(ref)=3
.nodeset v(bbo)=3.000864080095198
.nodeset v(neg)=3.000032323616218
.nodeset v(xopa.cl_clamp)=2.830177610216197
.nodeset v(xopa.clamp)=2.830177610157989
.nodeset v(xopa.claw_clamp)=2.830177610216197
.nodeset v(xopa.esdn)=3.000032324037614
.nodeset v(xopa.esdp)=3.000013159930267
.nodeset v(xopa.mid)=4.49999774999899
.nodeset v(xopa.n24207)=3.000013159930267
.nodeset v(xopa.n24458)=4.499316825072614
.nodeset v(xopa.n24659)=4.499997600228455
.nodeset v(xopa.n25248)=4.499997600272764
.nodeset v(xopa.n25397)=3.000030279930267
.nodeset v(xopa.n25415)=3.000030129975224
.nodeset v(xopa.n25921)=4.192198214776897
.nodeset v(xopa.n25929)=4.49999676504363
.nodeset v(xopa.n27785)=4.807797593020926
.nodeset v(xopa.n27793)=4.499998734955336
.nodeset v(xopa.n28438)=3.000030129975224
.nodeset v(xopa.n28678)=3.00003209988693
.nodeset v(xopa.n31303)=3.000032324037614
.nodeset v(xopa.n31389)=9.099995499997883
.nodeset v(xopa.n31737)=-0.09999550000215368
.nodeset v(xopa.n32236)=3.000032099887103
.nodeset v(xopa.n32347)=3.000032099887103
.nodeset v(xopa.n32510)=4.499975334962889
.nodeset v(xopa.n36262)=2.830177610216197
.nodeset v(xopa.n37029)=-11.01571518239984
.nodeset v(xopa.n37037)=2.924727689699107
.nodeset v(xopa.n39124)=-11.01486088136366
.nodeset v(xopa.n39892)=4.499765030610311
.nodeset v(xopa.n45999)=3.000864080095198
.nodeset v(xopa.n46041)=-11.01466261042515
.nodeset v(xopa.n55560)=4.499997749999249
.nodeset v(xopa.n56849)=4.499997749999249
.nodeset v(xopa.n57321)=4.499997749999249
.nodeset v(xopa.n57325)=4.499997749999249
.nodeset v(xopa.n59739)=73.39999774999899
.nodeset v(xopa.n59743)=4.499997749999249
.nodeset v(xopa.n59747)=4.499997749999249
.nodeset v(xopa.n59865)=4.499997749999249
.nodeset v(xopa.n59881)=4.499997749999249
.nodeset v(xopa.n59905)=-64.40000225000102
.nodeset v(xopa.n65567)=269.499997749999
.nodeset v(xopa.n65575)=4.499997749999249
.nodeset v(xopa.n65579)=4.499997749999249
.nodeset v(xopa.n65697)=4.499997749999249
.nodeset v(xopa.n65713)=4.499997749999249
.nodeset v(xopa.n65737)=-260.500002250001
.nodeset v(xopa.n68774)=2.830177610224914
.nodeset v(xopa.n72064)=8.974315194040424
.nodeset v(xopa.n72073)=0.03521429244204482
.nodeset v(xopa.n72391)=0.03521429244204482
.nodeset v(xopa.n72398)=8.974315194040424
.nodeset v(xopa.n81574)=4.499997741694839
.nodeset v(xopa.n81664)=4.49999774159479
.nodeset v(xopa.n81756)=4.49999774999899
.nodeset v(xopa.n158495)=2.830177610216197
.nodeset v(xopa.n161737)=4.503000242347959
.nodeset v(xopa.n161937)=3.000864080095198
.nodeset v(xopa.n1356061)=-1.319822381479653
.nodeset v(xopa.n1356115)=7.030177601811997
.nodeset v(xopa.n1356333)=-1.319822389783804
.nodeset v(xopa.n1356345)=-1.319822381479653
.nodeset v(xopa.n1356409)=7.030177601811997
.nodeset v(xopa.n1356429)=7.030177610216197
.nodeset v(xopa.n2402147)=4.499997600243427
.nodeset v(xopa.n2402155)=4.49999774996605
.nodeset v(xopa.n2419074)=2.830177610224914
.nodeset v(xopa.n2425287)=4.49999774999899
.nodeset v(xopa.n2425309)=8.999995495497886
.nodeset v(xopa.n2425325)=4.504497839572619e-06
.nodeset v(xopa.n2525790)=2.830177610224914
.nodeset v(xopa.n2526890)=2.830177610224914
.nodeset v(xopa.sw_ol_opax197)=4.49999774999899
.nodeset v(xopa.v11)=4.499997741694839
.nodeset v(xopa.v12)=4.49999774159479
.nodeset v(xopa.vcc_b)=8.999995499997883
.nodeset v(xopa.vcc_clp)=8.974315189566108
.nodeset v(xopa.vclp)=2.830177610216197
.nodeset v(xopa.vee_b)=4.499997846327118e-06
.nodeset v(xopa.vee_clp)=0.03521429690682826
.nodeset v(xopa.vimon)=4.503000242347959
.nodeset v(xopa.vout_s)=3.000864080095198
.nodeset v(xopa.vsense)=2.830177610224914
.nodeset v(xopa.x_u1.3)=0
.nodeset v(xopa.x_u1.4)=0
.nodeset v(xopa.x_u1.5)=0
.nodeset v(xopa.x_u1.6)=0
.nodeset v(xopa.x_u1.7)=0.833786412648769
.nodeset v(xopa.x_u1.8)=0.833786412648769
.nodeset v(xopa.x_u4.e1_int1)=1.712e-05
.nodeset v(xopa.x_u6.g1_int1)=-1.499965650112059
.nodeset v(xopa.x_u10.gvo+_int1)=0
.nodeset v(xopa.x_u10.gvo-_int1)=0
.nodeset v(xopa.x_u11.gvo+_int1)=0
.nodeset v(xopa.x_u11.gvo-_int1)=0
.nodeset v(xopa.x_u12.gvo+_int1)=0
.nodeset v(xopa.x_u12.gvo-_int1)=0
.nodeset v(xopa.x_u16.gsw+_int1)=0
.nodeset v(xopa.x_u18.g1_int1)=2.568030616967505e-05
.nodeset v(xopa.x_u18.g1_int2)=0.003002492348969099
.nodeset v(xopa.x_u19.g1_int1)=3.520979244336578e-05
.nodeset v(xopa.x_u19.g1_int2)=-0.003002492348969099
.nodeset v(xopa.x_u22.g1_int1)=0
.nodeset v(xopa.x_u23.g1_int1)=0
.nodeset v(xopa.x_u26.g1_int1)=3.002492348969099e-06
.nodeset v(xopa.x_u27.g1_int1)=0
.nodeset v(xopa.x_u30.g1_int1)=-2.241505104357694e-11
.nodeset v(xopa.x_u31.g1_int1)=-1.669920189517615e-06
.nodeset v(xopa.x_u32.g1_int1)=-15.51470348512521
.nodeset v(xopa.x_u35.g1_int1)=0
.nodeset v(xopa.x_u36.3)=0
.nodeset v(xopa.x_u36.5)=0
.nodeset v(xopa.x_u37.3)=0
.nodeset v(xopa.x_u37.5)=0

.include "D:/ms_xsp/s05_replacement_bourns_20261118/OPAx197.LIB"
.options method=trap reltol=1e-4 trtol=3 temp=27
.end
