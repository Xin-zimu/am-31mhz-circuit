* S05-06. Source SHA256 7e0a749654534daf110635fcbf6e34691a7ba08cefdcd1a34e5137e1d6af7757
.control
set ngbehavior=ps
source D:/ms_xsp/s05_replacement_bourns_20261118/G44_D30_source.cir
set filetype=binary
set num_threads=1
save v(src) v(input) v(port) v(b1) v(c1) v(e1) v(b2) v(c2) v(e2) v(ee) v(rf) v(det) v(out) i(vsup) v(bbin) v(ref) v(bbo) v(final)
tran 0.5n 450u 150u 0.5n
write D:/ms_xsp/s05_replacement_bourns_20261118/G44_D30.raw
quit
.endc
.end
