* OPA197 actual passive reference, no imposed node initial conditions
VSUP vcc 0 9
VIN out 0 DC 0.2 AC 1
* Passive 3 V reference, isolated output, noninverting gain.
RVT vcc ref 20k
RVB ref 0 10k
CVREF ref 0 10u
CCOUP out bbin 100n
RBIAS bbin ref 100k
RG neg ref 10k
RFB bbo neg 430000
XOPA bbin neg vcc 0 bbo OPAx197
ROUT bbo final 100
RBBLOAD final 0 1000000.0
CLOAD final 0 100p

.include "D:/ms_xsp/s05_replacement_bourns_20261118/OPAx197.LIB"
.options method=trap reltol=1e-4 trtol=3 temp=27
.end
