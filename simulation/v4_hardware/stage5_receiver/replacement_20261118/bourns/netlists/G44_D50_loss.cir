* S05-06. Source SHA256 3c00b1741dfc7b04f1ef6ff2e21ff529a2acf8b4fe0aab0d99596515689dcaf9
.control
set ngbehavior=ps
source D:/ms_xsp/s05_replacement_bourns_20261118/G44_D50_loss_source.cir
set filetype=binary
set num_threads=1
save v(src) v(input) v(port) v(b1) v(c1) v(e1) v(b2) v(c2) v(e2) v(ee) v(rf) v(det) v(out) i(vsup) v(bbin) v(ref) v(bbo) v(final)
tran 0.5n 450u 150u 0.5n
write D:/ms_xsp/s05_replacement_bourns_20261118/G44_D50_loss.raw
quit
.endc
.end
