* S05-08 purchasable-part loaded fixture; original active stages unchanged
CSEL input tank1 15p
CK tank1 tank2 2.4p
COUT tank2 port 11p
RPORT port 0 1Meg
RCT1 tank1 ctl1 0.438562250849
CTUNE1 ctl1 0 29.2662581673p
RLOSS1 tank1 ln1 2.74638029777
LSEL1 ln1 0 564n
CSELF1 tank1 0 1.34735616546p
RCT2 tank2 ctl2 0.215608562928
CTUNE2 ctl2 0 59.5295283337p
RLOSS2 tank2 ln2 1.83092019851
LSEL2 ln2 0 376n
CSELF2 tank2 0 1.34735616546p
