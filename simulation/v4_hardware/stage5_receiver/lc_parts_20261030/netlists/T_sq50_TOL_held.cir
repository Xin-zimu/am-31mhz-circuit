* S05-06. Source SHA256 f0f384c600bf6cc8308729e92b87276e52b5c656544c5bd817dd4505b8ee7cb6
.control
set ngbehavior=ps
source D:/ms_xsp/s05_parts_tran_20261030/T_sq50_TOL_held_source.cir
set filetype=binary
set num_threads=1
save v(src) v(input) v(port) v(b1) v(c1) v(e1) v(b2) v(c2) v(e2) v(ee) v(rf) v(det) v(out) i(vsup) v(bbin) v(ref) v(bbo) v(final)
tran 0.5n 200u 100u 0.5n
write D:/ms_xsp/s05_parts_tran_20261030/T_sq50_TOL_held.raw
quit
.endc
.end
