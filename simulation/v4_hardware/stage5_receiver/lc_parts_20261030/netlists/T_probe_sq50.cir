* S05-06. Source SHA256 87a250ca36e6772520b19b9eaa214445a8dd9277cf05ffa42d9e74d4fa1368f5
.control
set ngbehavior=ps
source D:/ms_xsp/s05_parts_tran_20261030/T_probe_sq50_source.cir
set filetype=binary
set num_threads=1
save v(src) v(input) v(port) v(b1) v(c1) v(e1) v(b2) v(c2) v(e2) v(ee) v(rf) v(det) v(out) i(vsup) v(bbin) v(ref) v(bbo) v(final)
tran 0.5n 100u 0u 0.5n
write D:/ms_xsp/s05_parts_tran_20261030/T_probe_sq50.raw
quit
.endc
.end
