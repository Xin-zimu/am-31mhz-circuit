* S05-06. Source SHA256 749dde4056cc0f216f33f39dad8c14fe4f0086ad4ac9f4d6d8c20486bafbb49e
.control
set ngbehavior=ps
source D:/ms_xsp/s05_parts_tran_20261030/T_sq50_Ac20_source.cir
set filetype=binary
set num_threads=1
save v(src) v(input) v(port) v(b1) v(c1) v(e1) v(b2) v(c2) v(e2) v(ee) v(rf) v(det) v(out) i(vsup) v(bbin) v(ref) v(bbo) v(final)
tran 0.5n 200u 100u 0.5n
write D:/ms_xsp/s05_parts_tran_20261030/T_sq50_Ac20.raw
quit
.endc
.end
