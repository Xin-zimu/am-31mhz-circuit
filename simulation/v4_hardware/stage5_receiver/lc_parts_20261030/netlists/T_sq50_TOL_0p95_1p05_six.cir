* S05-06. Source SHA256 029cdd5d552e4b875a4b3f6f20e5fd2c6d1c7b2205b1dfc09772706f8e9d82ab
.control
set ngbehavior=ps
source D:/ms_xsp/s05_parts_tran_20261030/T_sq50_TOL_0p95_1p05_six_source.cir
set filetype=binary
set num_threads=1
save v(src) v(input) v(port) v(b1) v(c1) v(e1) v(b2) v(c2) v(e2) v(ee) v(rf) v(det) v(out) i(vsup) v(bbin) v(ref) v(bbo) v(final)
tran 0.5n 400u 100u 0.5n
write D:/ms_xsp/s05_parts_tran_20261030/T_sq50_TOL_0p95_1p05_six.raw
quit
.endc
.end
