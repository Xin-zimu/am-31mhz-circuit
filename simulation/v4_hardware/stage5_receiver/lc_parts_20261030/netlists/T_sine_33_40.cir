* S05-06. Source SHA256 dfef49d28577d96274f04c76242d23e4aa6a4f6af16673567e1ef147480fd7e5
.control
set ngbehavior=ps
source D:/ms_xsp/s05_parts_tran_20261030/T_sine_33_40_source.cir
set filetype=binary
set num_threads=1
save v(src) v(input) v(port) v(b1) v(c1) v(e1) v(b2) v(c2) v(e2) v(ee) v(rf) v(det) v(out) i(vsup) v(bbin) v(ref) v(bbo) v(final)
tran 0.5n 200u 100u 0.5n
write D:/ms_xsp/s05_parts_tran_20261030/T_sine_33_40.raw
quit
.endc
.end
