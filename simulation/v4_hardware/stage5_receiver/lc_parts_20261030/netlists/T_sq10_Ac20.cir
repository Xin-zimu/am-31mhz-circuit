* S05-06. Source SHA256 a4a7763547b51039e549329587eb1ab1050cc1eff518facd5b0b71fec9a81499
.control
set ngbehavior=ps
source D:/ms_xsp/s05_parts_tran_20261030/T_sq10_Ac20_source.cir
set filetype=binary
set num_threads=1
save v(src) v(input) v(port) v(b1) v(c1) v(e1) v(b2) v(c2) v(e2) v(ee) v(rf) v(det) v(out) i(vsup) v(bbin) v(ref) v(bbo) v(final)
tran 0.5n 200u 100u 0.5n
write D:/ms_xsp/s05_parts_tran_20261030/T_sq10_Ac20.raw
quit
.endc
.end
