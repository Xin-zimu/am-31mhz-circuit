* A2 topology; loss approximation at 31 MHz, Q=50, Cp=1p
CSEL input tank1 14.529p
RLOSS1 tank1 ln1 1.92246620844
LSEL1 ln1 0 493.5n
CSELF1 tank1 0 1p
CTUNE1 tank1 0 36.919456091459054p
CK tank1 tank2 2.485p
RLOSS2 tank2 ln2 1.92246620844
LSEL2 ln2 0 493.5n
CSELF2 tank2 0 1p
CTUNE2 tank2 0 43.15945609145905p
COUT tank2 port 10.81p
RPORT port 0 1Meg
