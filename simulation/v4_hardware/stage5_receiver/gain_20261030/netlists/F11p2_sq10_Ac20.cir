* S05-06. Source SHA256 bde53d20c4abaec4e94baf91719bada31e474bfd14ee16dcb615a70b955d39fc
.control
set ngbehavior=ps
source D:/ms_xsp/s05_gain_20261030/F11p2_sq10_Ac20_source.cir
set filetype=binary
set num_threads=1
save v(src) v(input) v(port) v(b1) v(c1) v(e1) v(b2) v(c2) v(e2) v(ee) v(rf) v(det) v(out) i(vsup) v(bbin) v(ref) v(bbo) v(final)
tran 0.5n 200u 100u 0.5n
write D:/ms_xsp/s05_gain_20261030/F11p2_sq10_Ac20.raw
quit
.endc
.end
