* S05-06. Source SHA256 7b9413e7cadfd56e65c2beeb8d8f4e12f1f460e4cf3e1df0edf25a02e853ee30
.control
set ngbehavior=ps
source D:/ms_xsp/s05_gain_20261030/F22_sine_clean_source.cir
set filetype=binary
set num_threads=1
save v(src) v(input) v(port) v(b1) v(c1) v(e1) v(b2) v(c2) v(e2) v(ee) v(rf) v(det) v(out) i(vsup) v(bbin) v(ref) v(bbo) v(final)
tran 0.5n 200u 100u 0.5n
write D:/ms_xsp/s05_gain_20261030/F22_sine_clean.raw
quit
.endc
.end
