* S05-06. Source SHA256 6c996258a4ba242ddf8b390826fc22fe5ead2da2ce198c6690783be9fe1c4399
.control
set ngbehavior=ps
source D:/ms_xsp/s05_gain_20261030/F22_sq10_pre_gear_source.cir
set filetype=binary
set num_threads=1
save v(src) v(input) v(port) v(b1) v(c1) v(e1) v(b2) v(c2) v(e2) v(ee) v(rf) v(det) v(out) i(vsup) v(bbin) v(ref) v(bbo) v(final)
tran 0.5n 400u 100u 0.5n
write D:/ms_xsp/s05_gain_20261030/F22_sq10_pre_gear.raw
quit
.endc
.end
