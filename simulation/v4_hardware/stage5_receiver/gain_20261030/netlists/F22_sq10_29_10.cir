* S05-06. Source SHA256 d6367f563858846a011de052b1b7efcc7e61043db85472e4febb10c6ff4eba2d
.control
set ngbehavior=ps
source D:/ms_xsp/s05_gain_20261030/F22_sq10_29_10_source.cir
set filetype=binary
set num_threads=1
save v(src) v(input) v(port) v(b1) v(c1) v(e1) v(b2) v(c2) v(e2) v(ee) v(rf) v(det) v(out) i(vsup) v(bbin) v(ref) v(bbo) v(final)
tran 0.5n 200u 100u 0.5n
write D:/ms_xsp/s05_gain_20261030/F22_sq10_29_10.raw
quit
.endc
.end
