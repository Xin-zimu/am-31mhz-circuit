* S05-06. Source SHA256 b747d4bac371f943b029bd564af4b6453418c96c2794415b4cfa4989a03d1222
.control
set ngbehavior=ps
source D:/ms_xsp/s05_gain_20261030/F22_sq10_warm_source.cir
set filetype=binary
set num_threads=1
save v(src) v(input) v(port) v(b1) v(c1) v(e1) v(b2) v(c2) v(e2) v(ee) v(rf) v(det) v(out) i(vsup) v(bbin) v(ref) v(bbo) v(final)
tran 0.5n 400u 100u 0.5n uic
write D:/ms_xsp/s05_gain_20261030/F22_sq10_warm.raw
quit
.endc
.end
