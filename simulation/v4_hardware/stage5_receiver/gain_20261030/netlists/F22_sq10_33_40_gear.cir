* S05-06. Source SHA256 e8c2d40419b7695388dae819983b94d4dd3dbdd6a5bdd661e715cdb5b3925877
.control
set ngbehavior=ps
source D:/ms_xsp/s05_gain_20261030/F22_sq10_33_40_gear_source.cir
set filetype=binary
set num_threads=1
save v(src) v(input) v(port) v(b1) v(c1) v(e1) v(b2) v(c2) v(e2) v(ee) v(rf) v(det) v(out) i(vsup) v(bbin) v(ref) v(bbo) v(final)
tran 0.5n 200u 100u 0.5n
write D:/ms_xsp/s05_gain_20261030/F22_sq10_33_40_gear.raw
quit
.endc
.end
