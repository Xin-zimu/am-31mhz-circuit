* S05-06. Source SHA256 71a8d626413595f83956e7d791c7a3e6c6102936e8caf30dd7919a9b1a4487ba
.control
set ngbehavior=ps
source D:/ms_xsp/s05_gain_20261030/F22_sine_29_10_gear_source.cir
set filetype=binary
set num_threads=1
save v(src) v(input) v(port) v(b1) v(c1) v(e1) v(b2) v(c2) v(e2) v(ee) v(rf) v(det) v(out) i(vsup) v(bbin) v(ref) v(bbo) v(final)
tran 0.5n 200u 100u 0.5n
write D:/ms_xsp/s05_gain_20261030/F22_sine_29_10_gear.raw
quit
.endc
.end
