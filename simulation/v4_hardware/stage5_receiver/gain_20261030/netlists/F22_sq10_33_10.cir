* S05-06. Source SHA256 f7225d2e351ee10e4d38152ae17e7f7a088f4179c805bed3ffb8b00f802b5cea
.control
set ngbehavior=ps
source D:/ms_xsp/s05_gain_20261030/F22_sq10_33_10_source.cir
set filetype=binary
set num_threads=1
save v(src) v(input) v(port) v(b1) v(c1) v(e1) v(b2) v(c2) v(e2) v(ee) v(rf) v(det) v(out) i(vsup) v(bbin) v(ref) v(bbo) v(final)
tran 0.5n 200u 100u 0.5n
write D:/ms_xsp/s05_gain_20261030/F22_sq10_33_10.raw
quit
.endc
.end
