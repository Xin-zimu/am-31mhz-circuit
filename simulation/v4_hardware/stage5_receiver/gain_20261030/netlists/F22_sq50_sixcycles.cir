* S05-06. Source SHA256 7fda1882276c3200fb29c0402cdfe65f3362a62270026bc55f84d363a64ab1ee
.control
set ngbehavior=ps
source D:/ms_xsp/s05_gain_20261030/F22_sq50_sixcycles_source.cir
set filetype=binary
set num_threads=1
save v(src) v(input) v(port) v(b1) v(c1) v(e1) v(b2) v(c2) v(e2) v(ee) v(rf) v(det) v(out) i(vsup) v(bbin) v(ref) v(bbo) v(final)
tran 0.5n 400u 100u 0.5n
write D:/ms_xsp/s05_gain_20261030/F22_sq50_sixcycles.raw
quit
.endc
.end
