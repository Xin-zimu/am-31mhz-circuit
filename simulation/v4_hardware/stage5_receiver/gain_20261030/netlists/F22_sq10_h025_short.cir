* S05-06. Source SHA256 5d992cef0929ecd0cd97dd3566415dab5c41eca65d4ea244091bc752b746d066
.control
set ngbehavior=ps
source D:/ms_xsp/s05_gain_20261030/F22_sq10_h025_short_source.cir
set filetype=binary
set num_threads=1
save v(src) v(input) v(port) v(b1) v(c1) v(e1) v(b2) v(c2) v(e2) v(ee) v(rf) v(det) v(out) i(vsup) v(bbin) v(ref) v(bbo) v(final)
tran 0.25n 100u 50u 0.25n
write D:/ms_xsp/s05_gain_20261030/F22_sq10_h025_short.raw
quit
.endc
.end
