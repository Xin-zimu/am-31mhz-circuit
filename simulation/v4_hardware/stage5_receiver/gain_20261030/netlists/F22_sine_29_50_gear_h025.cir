* S05-06. Source SHA256 561e302e32961c435eb9b2ea3a30730f7245643ebc0ce2507aaee89a8fd56b4a
.control
set ngbehavior=ps
source D:/ms_xsp/s05_gain_20261030/F22_sine_29_50_gear_h025_source.cir
set filetype=binary
set num_threads=1
save v(src) v(input) v(port) v(b1) v(c1) v(e1) v(b2) v(c2) v(e2) v(ee) v(rf) v(det) v(out) i(vsup) v(bbin) v(ref) v(bbo) v(final)
tran 0.25n 200u 100u 0.25n
write D:/ms_xsp/s05_gain_20261030/F22_sine_29_50_gear_h025.raw
quit
.endc
.end
