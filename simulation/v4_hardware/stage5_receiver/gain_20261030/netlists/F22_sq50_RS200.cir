* S05-06. Source SHA256 009b18f3e1098bd716c6e47a020e3e9a078d84173106b54cf38d3f876ccc8256
.control
set ngbehavior=ps
source D:/ms_xsp/s05_gain_20261030/F22_sq50_RS200_source.cir
set filetype=binary
set num_threads=1
save v(src) v(input) v(port) v(b1) v(c1) v(e1) v(b2) v(c2) v(e2) v(ee) v(rf) v(det) v(out) i(vsup) v(bbin) v(ref) v(bbo) v(final)
tran 0.5n 200u 100u 0.5n
write D:/ms_xsp/s05_gain_20261030/F22_sq50_RS200.raw
quit
.endc
.end
