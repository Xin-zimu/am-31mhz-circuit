* S05-06. Source SHA256 70e8accd5f53b98c402d6ace4032dd5b611008b85d8ac937677f859a79009f72
.control
set ngbehavior=ps
source D:/ms_xsp/s05_gain_20261030/F22_sq50_Ac20_gear_source.cir
set filetype=binary
set num_threads=1
save v(src) v(input) v(port) v(b1) v(c1) v(e1) v(b2) v(c2) v(e2) v(ee) v(rf) v(det) v(out) i(vsup) v(bbin) v(ref) v(bbo) v(final)
tran 0.5n 200u 100u 0.5n
write D:/ms_xsp/s05_gain_20261030/F22_sq50_Ac20_gear.raw
quit
.endc
.end
