* S05-06. Source SHA256 1e1ebb6d8abb9e0fa410f4d188581ec76e6df92019efdd9df7fafbb1a71478b0
.control
set ngbehavior=ps
source D:/ms_xsp/s05_gain_20261030/F22_sq10_Ac20_gear_source.cir
set filetype=binary
set num_threads=1
save v(src) v(input) v(port) v(b1) v(c1) v(e1) v(b2) v(c2) v(e2) v(ee) v(rf) v(det) v(out) i(vsup) v(bbin) v(ref) v(bbo) v(final)
tran 0.5n 200u 100u 0.5n
write D:/ms_xsp/s05_gain_20261030/F22_sq10_Ac20_gear.raw
quit
.endc
.end
