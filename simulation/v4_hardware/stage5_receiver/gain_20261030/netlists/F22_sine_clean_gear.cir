* S05-06. Source SHA256 796c3e09138bdc63f07820d978a4b8ef1fec6eee12423757f7c8955322a261e8
.control
set ngbehavior=ps
source D:/ms_xsp/s05_gain_20261030/F22_sine_clean_gear_source.cir
set filetype=binary
set num_threads=1
save v(src) v(input) v(port) v(b1) v(c1) v(e1) v(b2) v(c2) v(e2) v(ee) v(rf) v(det) v(out) i(vsup) v(bbin) v(ref) v(bbo) v(final)
tran 0.5n 200u 100u 0.5n
write D:/ms_xsp/s05_gain_20261030/F22_sine_clean_gear.raw
quit
.endc
.end
