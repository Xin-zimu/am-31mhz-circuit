* S05-06. Source SHA256 4890d97cbb41b18e14e6c23b1884693164f119fd267451a125d4501be0e28e98
.control
set ngbehavior=ps
source D:/ms_xsp/s05_gain_20261030/BB22_sine_noic_source.cir
set filetype=binary
set num_threads=1
save v(out) v(bbin) v(ref) v(bbo) v(final) i(vsup)
tran 20n 400u 100u 20n
write D:/ms_xsp/s05_gain_20261030/BB22_sine_noic.raw
quit
.endc
.end
