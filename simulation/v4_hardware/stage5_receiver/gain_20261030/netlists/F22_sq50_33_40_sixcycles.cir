* S05-06. Source SHA256 64dc776782f1d0b68f1bff1e14f3641baf16d408fc29f35dee5331425c1fca5f
.control
set ngbehavior=ps
source D:/ms_xsp/s05_gain_20261030/F22_sq50_33_40_sixcycles_source.cir
set filetype=binary
set num_threads=1
save v(src) v(input) v(port) v(b1) v(c1) v(e1) v(b2) v(c2) v(e2) v(ee) v(rf) v(det) v(out) i(vsup) v(bbin) v(ref) v(bbo) v(final)
tran 0.5n 400u 100u 0.5n
write D:/ms_xsp/s05_gain_20261030/F22_sq50_33_40_sixcycles.raw
quit
.endc
.end
