* S05-06. Source SHA256 3472fc305e1dd1f3c39334a7562b60e563b8c736a36af79b991f0e48b117c311
.control
set ngbehavior=ps
source D:/ms_xsp/s05_gain_20261030/I_sq10_source.cir
set filetype=binary
set num_threads=1
save v(src) v(input) v(port) v(b1) v(c1) v(e1) v(b2) v(c2) v(e2) v(ee) v(rf) v(det) v(out) i(vsup) v(bbin) v(ref) v(bbo) v(final)
tran 0.5n 400u 100u 0.5n
write D:/ms_xsp/s05_gain_20261030/I_sq10.raw
quit
.endc
.end
