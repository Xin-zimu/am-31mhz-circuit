* RC tolerance probe
V1 in 0 PULSE(0 1 0 1n 1n 5u 10u)
R1 in out 1k
C1 out 0 100n
.options reltol=1e-9 trtol=0.1
.end
