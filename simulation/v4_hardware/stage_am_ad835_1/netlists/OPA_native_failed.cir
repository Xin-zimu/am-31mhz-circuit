LM393P Stage 1 - RC oscillator, PWM threshold, amplitude potentiometer
* TI LM393 macromodel from installed NI Multisim master database LM393/TI.
* U1A: DIP pins IN+=3 IN-=2 V+=8 GND=4 OUT=1
* U1B: DIP pins IN+=5 IN-=6 V+=8 GND=4 OUT=7
V5 V5 0 5
CDEC V5 0 100n
CBULK V5 0 10u
RPU1 V5 OSC 2.2k
RHT V5 HYST 30k
RHB HYST 0 10k
RHF OSC HYST 20k
RFIX OSC FSET 22k
RVRF FSET RAMP 15288.86443
CT RAMP 0 1n
XU1A HYST RAMP V5 0 OSC LM393_TI
* VDUTY resistor chain: 10k + 10k potentiometer + 4.7k.
RDT V5 DUTY_TOP 10k
RVDT DUTY_TOP DUTY 9623.899007
RVDB DUTY DUTY_BOT 376.1009934
RDB DUTY_BOT 0 4.7k
XU1B DUTY RAMP V5 0 PWM_RAW LM393_TI
RPU2 V5 PWM_RAW 2.2k
* 20k amplitude potentiometer, wiper at V1, includes specified load.
RVAT PWM_RAW V1 1847.927767
RVAB V1 0 18152.07223
RINPUT V1 0 1000000
CINPUT V1 0 15p
*****************************************************************************

* (C) Copyright 2002 Texas Instruments Incorporated. All rights reserved.

*****************************************************************************

** This model is designed as an aid for customers of Texas Instruments.

** TI and its licensors and suppliers make no warranties, either expressed

** or implied, with respect to this model, including the warranties of

** merchantability or fitness for a particular purpose.  The model is

** provided solely on an as is basis.  The entire risk as to its quality

** and performance is with the customer.

*****************************************************************************

* LM393 VOLTAGE COMPARATOR "MACROMODEL" SUBCIRCUIT

* CREATED USING PARTS VERSION 4.03 ON 03/07/90 AT 14:17

* REV (N/A)

* CONNECTIONS:   NON-INVERTING INPUT

*                | INVERTING INPUT

*                | | POSITIVE POWER SUPPLY

*                | | | NEGATIVE POWER SUPPLY

*                | | | | OPEN COLLECTOR OUTPUT

*                | | | | |

.SUBCKT LM393_TI    1 2 3 4 5

*

  F1    9  3 V1 1

  IEE   3  7 DC 100.0E-6

  VI1  21  1 DC .75

  VI2  22  2 DC .75

  Q1    9 21  7 QIN

  Q2    8 22  7 QIN

  Q3    9  8  4 QMO

  Q4    8  8  4 QMI

.MODEL QIN PNP(IS=800.0E-18 BF=2.000E3)

.MODEL QMI NPN(IS=800.0E-18 BF=1002)

.MODEL QMO NPN(IS=800.0E-18 BF=1000 CJC=1E-15 TR=807.4E-9)

  E1   10  4  9  4  1

  V1   10 11 DC 0

  Q5    5 11  4 QOC

.MODEL QOC NPN(IS=800.0E-18 BF=20.29E3 CJC=1E-15 TF=942.6E-12 TR=543.8E-9)

  DP    4  3 DX

  RP 3  4 46.3E3

.MODEL DX  D(IS=800.0E-18)

*

.ENDS

VN vn 0 -5
VP vp 0 5
XPRE V1 vb vp vn vb OPAx197
RM vb sum 100k
RN vn sum 125k
RG sum 0 12946.979038224414
XPOST sum x vp vn x OPAx197
RX x 0 100k
CX x 0 2p
IX x 0 1e-05
.SUBCKT OPAx197 IN+ IN- VCC VEE OUT
*****************************************************************************
C_C1          N24458 N24659  723.4P
C_C10         N37029 N37037  7.958U
C_C12         N39124 N39892  10.6P
C_C13         0 N2425309  1F
C_C14         0 N2425287  1U
C_C15         0 N2425325  1F
C_C16         MID N56849  1F
C_C17         MID N57325  1F
C_C18         MID N59747  1F
C_C19         MID N59865  1F
C_C2          N25921 N25929  497P
C_C20         MID N65579  1F
C_C21         MID N65697  1F
C_C22         MID N68774  1F
C_C23         N72398 MID  1F
C_C24         MID N72391  1F
C_C25         MID N81574  1P
C_C26         MID N81664  1P
C_C27         MID SW_OL_OPAx197   1N
C_C28         VCLP MID  1P
C_C29         VIMON MID  1P
C_C3          N27785 N27793  497P
C_C30         VOUT_S MID  1P
C_C31         N2402147 N2402155  723.4P
C_C32         MID N2419074  1F
C_C33         MID N2525790  2F
C_C34         MID N2526890  2F
C_C35         MID N36262  1.3F
C_C4          N32347 MID  1F
C_C5          CLAMP MID  113N
C_C_COM0      ESDP MID  6.4P
C_C_COM1      MID ESDN  6.4P
C_C_DIFF      ESDN ESDP  1.6P
E_E1          MID 0 N2425287 0 1
E_E2          N158495 MID CL_CLAMP MID 1
E_E3          N161937 MID OUT MID 1
G_G1          N24458 MID ESDP MID -454U
G_G12         CLAW_CLAMP MID N36262 MID -1M
G_G13         CL_CLAMP MID CLAW_CLAMP MID -1M
G_G15         N37029 MID CL_CLAMP N45999 -90.91
G_G16         N39124 MID N37037 MID -9.85
G_G18         VCC_B 0 VCC 0 -1
G_G19         VEE_B 0 VEE 0 -1
G_G2          N25415 N25397 N25248 MID -1M
G_G20         VCC_CLP MID N72398 MID -1M
G_G21         VEE_CLP MID N72391 MID -1M
G_G22         N1356345 MID N1356333 MID -1
G_G23         N1356409 MID N1356429 MID -1
G_G24         N2402147 MID N24659 MID -1
G_G25         N25248 MID N2402155 MID -4.54545K
G_G26         N2419074 MID VSENSE MID -1U
G_G27         N2525790 MID N2419074 MID -1U
G_G28         N2526890 MID N2525790 MID -1U
G_G29         N36262 MID N2526890 MID -1U
G_G3          N25921 MID VEE_B MID -68.4M
G_G4          N27785 MID VCC_B MID -68.4M
G_G5          N28678 N28438 N27793 N25929 -1M
G_G6          VSENSE MID CLAMP MID -1M
I_I_B         N24207 MID DC 5.25P
I_I_OS        ESDN MID DC 2.75P
I_I_Q         VCC VEE DC 1M
R_R1          IN+ ESDP R_NOISELESS 100
R_R10         MID N25921 R_NOISELESS 1
R_R11         MID N25929 R_NOISELESS 320
R_R12         N27793 N27785 R_NOISELESS 100MEG
R_R13         MID N27785 R_NOISELESS 1
R_R14         MID N27793 R_NOISELESS 320
R_R15         N28438 N25415 R_NOISELESS 1M
R_R16         N28678 N28438 R_NOISELESS 1K
R_R17         N31303 ESDN R_NOISELESS 1M
R_R18         MID N31389 R_NOISELESS 1T
R_R19         MID N31737 R_NOISELESS 1T
R_R2          IN- ESDN R_NOISELESS 100
R_R20         N32236 MID R_NOISELESS 1
R_R21         N32347 N32236 R_NOISELESS 1M
R_R22         MID N32510 R_NOISELESS 1MEG
R_R23         MID CLAMP R_NOISELESS 1MEG
R_R24         MID VSENSE R_NOISELESS 1K
R_R3          ESDP MID R_NOISELESS 1T
R_R32         MID CLAW_CLAMP R_NOISELESS 1K
R_R33         MID CL_CLAMP R_NOISELESS 1K
R_R34         N37037 N37029 R_NOISELESS 10K
R_R35         MID N37029 R_NOISELESS 1
R_R36         MID N37037 R_NOISELESS 1.13K
R_R4          MID ESDN R_NOISELESS 1T
R_R40         N39892 N39124 R_NOISELESS 10K
R_R41         MID N39124 R_NOISELESS 1
R_R42         MID N39892 R_NOISELESS 150M
R_R43         MID N46041 R_NOISELESS 1
R_R46         VCC_B 0 R_NOISELESS 1
R_R47         VCC_B N2425309 R_NOISELESS 1M
R_R48         N2425309 N2425287 R_NOISELESS 1MEG
R_R49         N2425287 0 R_NOISELESS 1T
R_R5          MID N24458 R_NOISELESS 1
R_R50         N2425287 N2425325 R_NOISELESS 1MEG
R_R51         N2425325 VEE_B R_NOISELESS 1M
R_R52         VEE_B 0 R_NOISELESS 1
R_R53         VCC_CLP MID R_NOISELESS 1T
R_R54         N55560 MID R_NOISELESS 1
R_R55         N56849 N55560 R_NOISELESS 1M
R_R56         VEE_CLP MID R_NOISELESS 1T
R_R57         N57321 MID R_NOISELESS 1
R_R58         N57325 N57321 R_NOISELESS 1M
R_R59         N59739 MID R_NOISELESS 1T
R_R6          N24659 N24458 R_NOISELESS 10K
R_R60         N59743 MID R_NOISELESS 1
R_R61         N59747 N59743 R_NOISELESS 1M
R_R62         N59865 N59881 R_NOISELESS 1M
R_R63         N59905 MID R_NOISELESS 1T
R_R64         N59881 MID R_NOISELESS 1
R_R65         N65567 MID R_NOISELESS 1T
R_R66         N65575 MID R_NOISELESS 1
R_R67         N65579 N65575 R_NOISELESS 1M
R_R68         N65697 N65713 R_NOISELESS 1M
R_R69         N65737 MID R_NOISELESS 1T
R_R7          MID N24659 R_NOISELESS 2.2
R_R70         N65713 MID R_NOISELESS 1
R_R71         N68774 VSENSE R_NOISELESS 1M
R_R72         VCC_B N72064 R_NOISELESS 1K
R_R73         N72064 N72398 R_NOISELESS 1M
R_R74         N72073 VEE_B R_NOISELESS 1K
R_R75         N72073 N72391 R_NOISELESS 1M
R_R76         MID VCC_CLP R_NOISELESS 1K
R_R77         VEE_CLP MID R_NOISELESS 1K
R_R78         N1356409 MID R_NOISELESS 1
R_R79         N1356345 MID R_NOISELESS 1
R_R8          N25415 N25397 R_NOISELESS 1K
R_R80         V11 N81574 R_NOISELESS 100
R_R81         V12 N81664 R_NOISELESS 100
R_R82         N81756 MID R_NOISELESS 1
R_R83         N81756 SW_OL_OPAx197  R_NOISELESS 100
R_R84         N158495 VCLP R_NOISELESS 100
R_R85         N2402155 N2402147 R_NOISELESS 10K
R_R86         MID N2402147 R_NOISELESS 1
R_R87         MID N2402155 R_NOISELESS 2.2
R_R88         MID N25248 R_NOISELESS 1
R_R89         MID N2419074 R_NOISELESS 1MEG
R_R9          N25929 N25921 R_NOISELESS 100MEG
R_R90         MID N2525790 R_NOISELESS 1MEG
R_R91         MID N2526890 R_NOISELESS 1MEG
R_R92         MID N36262 R_NOISELESS 1MEG
R_R_DIFF      ESDN ESDP R_NOISELESS 100MEG
R_RDUMMY      MID N45999 R_NOISELESS 32.5K
R_RX          N45999 N46041 R_NOISELESS 325K
R_RX1         MID N161737 R_NOISELESS 1T
R_RX2         VIMON N161737 R_NOISELESS 100
R_RX3         MID N161937 R_NOISELESS 1T
R_RX4         VOUT_S N161937 R_NOISELESS 100
V_VCM_MAX     N31389 VCC_B 100M
V_VCM_MIN     N31737 VEE_B -100M
V_V_GRN       N65737 MID -265
V_V_GRP       N65567 MID 265
V_V_ISCN      N59905 MID -68.9
V_V_ISCP      N59739 MID 68.9
V_V_ORN       N1356333 VCLP -4.15
V_V_ORP       N1356429 VCLP 4.2
X_H1          N45999 OUT N161737 MID BLOCK_DC_H1_OPAx197
X_H2          N1356115 N1356409 V12 MID BLOCK_DC_H2_OPAx197
X_H3          N1356061 N1356345 V11 MID BLOCK_DC_H3_OPAx197
X_S1          N1356061 CLAMP N1356061 CLAMP BLOCK_DC_S1_OPAx197
X_S2          CLAMP N1356115 CLAMP N1356115 BLOCK_DC_S2_OPAx197
X_U1          ESDP N24207 VNSE_OPAx197  PARAMS: FLW=0.1 GLF=0.1352 RNV=35.8
X_U10         VCC_CLP VEE_CLP VOUT_S MID N55560 N57321 CLAMP_AMP_LO_OPAx197  PARAMS: G=1
X_U11         N59739 N59905 VIMON MID N59743 N59881 CLAMP_AMP_LO_OPAx197  PARAMS: G=1
X_U12         N65567 N65737 N68774 MID N65575 N65713 CLAMP_AMP_HI_OPAx197  PARAMS: G=10
X_U16         MID N81756 N81574 N81664 OL_SENSE_OPAx197
X_U18         VIMON MID N72064 VCC_B CLAWP_OPAx197
X_U19         MID VIMON VEE_B N72073 CLAWN_OPAx197
X_U21         OUT VCC VEE ESD_OUT_OPAx197
X_U22         N59747 N59865 CL_CLAMP MID CL_SRC_OPAx197  PARAMS: GAIN=1 IPOS=1.1E1
+  INEG=-1.1E1
X_U23         N65579 N65697 CLAMP MID GR_SRC_OPAx197  PARAMS: GAIN=1 IPOS=4.8E1
+  INEG=-4.8E1
X_U25         SW_OL_OPAx197  MID N37029 N37037 SW_OL_OPAx197  PARAMS:
X_U26         VIMON MID VCC MID IQ_SRC_OPAx197  PARAMS: GAIN=1E-3
X_U27         MID VIMON MID VEE IQ_SRC_OPAx197  PARAMS: GAIN=1E-3
X_U30         N32347 N31303 MID N32510 AOL_1_OPAx197  PARAMS: GAIN=1E-4 IPOS=.5 INEG=-.5
X_U31         N32510 MID MID CLAMP AOL_2_OPAx197  PARAMS: GAIN=74.5E-3 IPOS=2.4
+  INEG=-2.4
X_U32         N39892 MID MID N46041 ZO_SRC_OPAx197  PARAMS: GAIN=66667 IPOS=5E4
+  INEG=-5E4
X_U35         N56849 N57325 CLAW_CLAMP MID CLAW_SRC_OPAx197  PARAMS: GAIN=1 IPOS=0.55E1
+  INEG=-0.55E1
X_U36         N24207 MID FEMT_OPAx197  PARAMS: NVRF=1.5
X_U37         ESDN MID FEMT_OPAx197  PARAMS: NVRF=1.5
X_U4          N25397 N24207 VOS_DRIFT_OPAx197  PARAMS: DC=1.712E-05 POL=1 DRIFT=0.5E-06
X_U5          ESDN ESDP VCC VEE ESD_IN_OPAx197
X_U6          N28678 MID N32236 MID N31389 N31737 VCM_CLAMP_OPAx197  PARAMS: GAIN=1
.MODEL R_NOISELESS RES (T_ABS=-273.15)
.ENDS OPAx197
*
.SUBCKT BLOCK_DC_H1_OPAx197  1 2 3 4
H_H1         3 4 VH_H1 1K
VH_H1         1 2 0V
.ENDS  BLOCK_DC_H1_OPAx197
*
.SUBCKT BLOCK_DC_H2_OPAx197  1 2 3 4
H_H2         3 4 VH_H2 1
VH_H2         1 2 0V
.ENDS  BLOCK_DC_H2_OPAx197
*
.SUBCKT BLOCK_DC_H3_OPAx197  1 2 3 4
H_H3         3 4 VH_H3 -1
VH_H3         1 2 0V
.ENDS  BLOCK_DC_H3_OPAx197
*
.SUBCKT BLOCK_DC_S1_OPAx197  1 2 3 4
S_S1         3 4 1 2 _S1
RS_S1         1 2 1G
.MODEL         _S1 VSWITCH ROFF=1E9 RON=10M VOFF=0.0V VON=10MV
.ENDS  BLOCK_DC_S1_OPAx197
*
.SUBCKT BLOCK_DC_S2_OPAx197  1 2 3 4
S_S2         3 4 1 2 _S2
RS_S2         1 2 1G
.MODEL         _S2 VSWITCH ROFF=1E9 RON=10M VOFF=0.0V VON=10MV
.ENDS  BLOCK_DC_S2_OPAx197
*
.SUBCKT AOL_1_OPAx197 VC+ VC- IOUT+ IOUT- PARAMS: GAIN=1E-4 IPOS=.5 INEG=-.5
G1 IOUT+ IOUT- VALUE={LIMIT(GAIN*V(VC+,VC-),INEG,IPOS)}
.ENDS  AOL_1_OPAx197
*
.SUBCKT AOL_2_OPAx197 VC+ VC- IOUT+ IOUT- PARAMS: GAIN=74.5E-3 IPOS=2.4 INEG=-2.4
G1 IOUT+ IOUT- VALUE={LIMIT(GAIN*V(VC+,VC-),INEG,IPOS)}
.ENDS  AOL_2_OPAx197
*
.SUBCKT CLAMP_AMP_HI_OPAx197 VC+ VC- VIN COM VO+ VO- PARAMS: G=10
GVO+ COM VO+ VALUE = {IF(V(VIN,COM)>V(VC+,COM),((V(VIN,COM)-V(VC+,COM))*G),0)}
GVO- COM VO- VALUE = {IF(V(VIN,COM)<V(VC-,COM),((V(VC-,COM)-V(VIN,COM))*G),0)}
.ENDS  CLAMP_AMP_HI_OPAx197
*
.SUBCKT CLAMP_AMP_LO_OPAx197 VC+ VC- VIN COM VO+ VO- PARAMS: G=1
GVO+ COM VO+ VALUE = {IF(V(VIN,COM)>V(VC+,COM),((V(VIN,COM)-V(VC+,COM))*G),0)}
GVO- COM VO- VALUE = {IF(V(VIN,COM)<V(VC-,COM),((V(VC-,COM)-V(VIN,COM))*G),0)}
.ENDS  CLAMP_AMP_LO_OPAx197
*
.SUBCKT CLAWN_OPAx197 VC+ VC- IOUT+ IOUT-
G1 IOUT+ IOUT- TABLE {(V(VC+,VC-))} =
+(0,        8.23E-6)
+(25.1799, 1.09E-03)
+(35.9712, 1.63E-03)
+(48.9209, 2.43E-03)
+(57.2662, 3.07E-03)
+(63.5971, 3.77E-03)
+(67.9137, 4.50E-03)
+(68.0576, 5.04E-03)
+(68.9,    1.80E-02)
.ENDS  CLAWN_OPAx197
*
.SUBCKT CLAWP_OPAx197 VC+ VC- IOUT+ IOUT-
G1 IOUT+ IOUT- TABLE {(V(VC+,VC-))} =
+(0,         8.3E-6)
+(16.5725, 7.01E-04)
+(30.5838, 1.38E-03)
+(45.0471, 2.11E-03)
+(62.6742, 3.09E-03)
+(67.9473, 3.49E-03)
+(68.2486, 5.04E-03)
+(68.9,    1.80E-02)
.ENDS  CLAWP_OPAx197
*
.SUBCKT CLAW_SRC_OPAx197 VC+ VC- IOUT+ IOUT- PARAMS: GAIN=1 IPOS=0.55E1 INEG=-0.55E1
G1 IOUT+ IOUT- VALUE={LIMIT(GAIN*V(VC+,VC-),INEG,IPOS)}
.ENDS  CLAW_SRC_OPAx197
*
.SUBCKT CL_SRC_OPAx197 VC+ VC- IOUT+ IOUT- PARAMS: GAIN=1 IPOS=1.1E1 INEG=-1.1E1
G1 IOUT+ IOUT- VALUE={LIMIT(GAIN*V(VC+,VC-),INEG,IPOS)}
.ENDS  CL_SRC_OPAx197
*
.SUBCKT ESD_IN_OPAx197 ESDN ESDP VCC VEE
.MODEL ESD_SW VSWITCH(RON=50 ROFF=1E12 VON=700E-3 VOFF=100E-3)
S1 ESDN VCC ESDN VCC ESD_SW
S2 ESDP VCC ESDP VCC ESD_SW
S3 VEE ESDN VEE ESDN ESD_SW
S4 VEE ESDP VEE ESDP ESD_SW
.ENDS  ESD_IN_OPAx197
*
.SUBCKT ESD_OUT_OPAx197 OUT VCC VEE
.MODEL ESD_SW VSWITCH(RON=50 ROFF=1E12 VON=700E-3 VOFF=100E-3)
S1 OUT VCC OUT VCC ESD_SW
S2 VEE OUT VEE OUT ESD_SW
.ENDS  ESD_OUT_OPAx197
*
.SUBCKT FEMT_OPAx197 1 2 PARAMS: NVRF=1.5
E1 3 0 5 0 10
R1 5 0 {1.184*PWR(NVRF,2)}
R2 5 0 {1.184*PWR(NVRF,2)}
G1 1 2 3 0 1E-6
.ENDS  FEMT_OPAx197
*
.SUBCKT GR_SRC_OPAx197 VC+ VC- IOUT+ IOUT- PARAMS: GAIN=1 IPOS=4.8E1 INEG=-4.8E1
G1 IOUT+ IOUT- VALUE={LIMIT(GAIN*V(VC+,VC-),INEG,IPOS)}
.ENDS  GR_SRC_OPAx197
*
.SUBCKT IQ_SRC_OPAx197 VC+ VC- IOUT+ IOUT- PARAMS: GAIN=1E-3
G1 IOUT+ IOUT- VALUE={IF( (V(VC+,VC-)<=0),0,GAIN*V(VC+,VC-) )}
.ENDS  IQ_SRC_OPAx197
*
.SUBCKT OL_SENSE_OPAx197 1  2  3  4
GSW+ 1 2 VALUE = {IF((V(3,1)>10E-3 | V(4,1)>10E-3),1,0)}
.ENDS  OL_SENSE_OPAx197
*
.SUBCKT SW_OL_OPAx197 SW_OL_OPAx197 MID CAP_L CAP_R
.MODEL OL_SW VSWITCH(RON=1E-3 ROFF=1E12 VON=900E-3 VOFF=800E-3)
S1 CAP_L CAP_R SW_OL_OPAx197 MID OL_SW
.ENDS  SW_OL_OPAx197
*
.SUBCKT VCM_CLAMP_OPAx197 VIN+ VIN- IOUT- IOUT+ VP+ VP- PARAMS: GAIN=1
G1 IOUT+ IOUT- VALUE={LIMIT(GAIN*V(VIN+,VIN-),V(VP-,VIN-), V(VP+,VIN-))}
.ENDS  VCM_CLAMP_OPAx197
*
.SUBCKT VNSE_OPAx197 1 2 PARAMS: FLW=0.1 GLF=0.1352 RNV=35.8
.MODEL DVN D KF={PWR(FLW,0.5)/1E11} IS=1.0E-16
I1 0 7 10E-3
I2 0 8 10E-3
D1 7 0 DVN
D2 8 0 DVN
E1 3 6 7 8 {GLF}
R1 3 0 1E9
R2 3 0 1E9
R3 3 6 1E9
E2 6 4 5 0 10
R4 5 0 {RNV}
R5 5 0 {RNV}
R6 3 4 1E9
R7 4 0 1E9
E3 1 2 3 4 1
.ENDS  VNSE_OPAx197
*
.SUBCKT VOS_DRIFT_OPAx197 VOS+ VOS- PARAMS: DC=1.712E-05 POL=1 DRIFT=0.5E-6
E1 VOS+ VOS- VALUE={DC+POL*DRIFT*(TEMP-27)}
.ENDS  VOS_DRIFT_OPAx197
*
.SUBCKT ZO_SRC_OPAx197 VC+ VC- IOUT+ IOUT- PARAMS: GAIN=66667 IPOS=5E4 INEG=-5E4
G1 IOUT+ IOUT- VALUE={LIMIT(GAIN*V(VC+,VC-),INEG,IPOS)}
.ENDS  ZO_SRC_OPAx197
.options reltol=1e-5 method=trap
.control
set filetype=binary
set num_threads=1
save v(v1) v(x) i(v5) i(vp) i(vn)
tran 20n 2m 1.5m 20n uic
write bb_prepost_a4_d10.raw
quit
.endc
.end
