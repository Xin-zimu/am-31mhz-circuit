* C3 numerical-consistency run: c4_trap_0p125n_2k_rtol1e5
* Circuit identical to c2_two_load.cir; numerical options only.
*   method=trap maxord=2 reltol=1e-5 trtol=7 tmax=0.125n tstep=0.25n tstop=5m tstart=3m rload=2k
VSUP vcc 0 PWL(0 0 1u 5)
* --- crystal Colpitts (unchanged from C1) ---
R1 vcc b 10k
R2 b 0 10k
Q1 vcc b e 2N3904
R3 e 0 4.7k
C1 b e 33p
C2 e 0 33p
C3 vcc 0 100n
C4 vcc 0 10u
CSTRAY b 0 1p
CX0 b 0 3.0p
VXM b xr 0
RM xr xl 30
LM xl xc 0.002637081993366925
CM xc 0 10.0f
* --- emitter follower buffer (unchanged from C1) ---
CIN e bf 1n
RBT vcc bf 10k
RBB bf 0 10k
QB vcc bf ef 2N3904
REB ef 0 330
COUTB ef bo 1n
* --- common-emitter gain stage (unchanged from C1) ---
CG bo bg 10n
RG1 vcc bg 22k
RG2 bg 0 4.7k
QG cg bg eg 2N3904
RCG vcc cg 1k
REG eg 0 56
COUTG cg out 10n
VSENSE out tp 0
.model 2N3904   NPN(Is=6.734f Xti=3 Eg=1.11 Vaf=74.03 Bf=416.4 Ne=1.259
+               Ise=6.734f Ikf=66.78m Xtb=1.5 Br=.7371 Nc=2 Isc=0 Ikr=0 Rc=1
+               Cjc=3.638p Mjc=.3085 Vjc=.75 Fc=.5 Cje=4.493p Mje=.2593 Vje=.75
+               Tr=239.5n Tf=301.2p Itf=.4 Vtf=4 Xtf=2 Rb=10)
.options method=trap maxord=2 reltol=1e-5 trtol=7 temp=27 tnom=27
CBI tp atten 10n
RSB atten rb 1000
RPB rb 0 1000
CB2 rb base 10n
RBT2 vcc base 10k
RBB2 base 0 10k
QBUF vcc base emit 2N3904
REB2 emit 0 330
CBO emit a 10n
RRETURN a 0 680
VY a y 0
RZT a z 100
RZB z 0 150.37593985
* INPUT FIXTURE ONLY: not an AD835 macro-model
RY y 0 100k
CY y 0 2p
RZ z 0 60k
CZ z 0 2p
IY y 0 -2.7e-05
IZ z 0 -0.0001

.control
set filetype=binary
set num_threads=1
op
print v(b) v(e) v(bf) v(ef) v(bg) v(eg) v(cg) @q1[ic] @qb[ic] @qg[ic]
save v(out) v(y) v(z) v(e) v(b) v(bf) v(ef) v(bg) v(eg) v(cg) i(vsup) i(vsense)
tran 0.5n 2.5m 2.45m 0.25n uic
write B_Z06_stress_nn.raw
quit
.endc
.end
