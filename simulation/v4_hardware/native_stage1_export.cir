** stage1_layout **
*
* NI Multisim to SPICE Netlist Export
* Generated by: xin
* Fri, Oct 09, 2026 17:40:45
*

*## Multisim Component V5 ##*
vV5 V5 0 dc 5 ac 0 0
+           distof1 0 0
+           distof2 0 0

*## Multisim Component CDEC ##*
cCDEC V5 0 1e-07

*## Multisim Component CBULK ##*
cCBULK V5 0 1e-05

*## Multisim Component RPU1 ##*
rRPU1 V5 OSC 2200 vresRPU1
.model vresRPU1 r(  )

*## Multisim Component RHT ##*
rRHT V5 HYST 30000 vresRHT
.model vresRHT r(  )

*## Multisim Component RHB ##*
rRHB HYST 0 10000 vresRHB
.model vresRHB r(  )

*## Multisim Component RHF ##*
rRHF OSC HYST 20000 vresRHF
.model vresRHF r(  )

*## Multisim Component RFIX ##*
rRFIX OSC FSET 22000 vresRFIX
.model vresRFIX r(  )

*## Multisim Component RVRF ##*
rRVRF FSET RAMP 15288.9 vresRVRF
.model vresRVRF r(  )

*## Multisim Component CT ##*
cCT RAMP 0 1e-09

*## Multisim Component U1A_-ECOMP1 ##*
xU1A_-ECOMP1 HYST RAMP V5 0 OSC LM393_OSC_V4
*****************************************************************************

* (C) Copyright 2002 Texas Instruments Incorporated. All rights reserved.

*****************************************************************************

** This model is designed as an aid for customers of Texas Instruments.

** TI and its licensors and suppliers make no warranties, either expressed

** or implied, with respect to this model, including the warranties of

** merchantability or fitness for a particular purpose.  The model is

** provided solely on an as is basis.  The entire risk as to its quality

** and performance is with the customer.

*****************************************************************************

* LM393 VOLTAGE COMPARATOR "MACROMODEL" SUBCIRCUIT

* CREATED USING PARTS VERSION 4.03 ON 03/07/90 AT 14:17

* REV (N/A)

* CONNECTIONS:   NON-INVERTING INPUT

*                | INVERTING INPUT

*                | | POSITIVE POWER SUPPLY

*                | | | NEGATIVE POWER SUPPLY

*                | | | | OPEN COLLECTOR OUTPUT

*                | | | | |

.SUBCKT LM393_OSC_V4    1 2 3 4 5

*

  F1    9  3 V1 1

  IEE   3  7 DC 100.0E-6

  VI1  21  1 DC .75

  VI2  22  2 DC .75

  Q1    9 21  7 QIN

  Q2    8 22  7 QIN

  Q3    9  8  4 QMO

  Q4    8  8  4 QMI

.MODEL QIN PNP(IS=800.0E-18 BF=2.000E3)

.MODEL QMI NPN(IS=800.0E-18 BF=1002)

.MODEL QMO NPN(IS=800.0E-18 BF=1000 CJC=1E-15 TR=807.4E-9)

  E1   10  4  9  4  1

  V1   10 11 DC 0

  Q5    5 11  4 QOC

.MODEL QOC NPN(IS=800.0E-18 BF=20.29E3 CJC=1E-15 TF=942.6E-12 TR=543.8E-9)

  DP    4  3 DX

  RP 3  4 46.3E3

.MODEL DX  D(IS=800.0E-18)

*

.ENDS

*## Multisim Component RDT ##*
rRDT V5 DUTY_TOP 10000 vresRDT
.model vresRDT r(  )

*## Multisim Component RVDT ##*
rRVDT DUTY_TOP DUTY 7362.47 vresRVDT
.model vresRVDT r(  )

*## Multisim Component RVDB ##*
rRVDB DUTY DUTY_BOT 2637.53 vresRVDB
.model vresRVDB r(  )

*## Multisim Component RDB ##*
rRDB DUTY_BOT 0 4700 vresRDB
.model vresRDB r(  )

*## Multisim Component U1B_-ECOMP2 ##*
xU1B_-ECOMP2 DUTY RAMP V5 0 PWM_RAW LM393_PWM_V4
*****************************************************************************

* (C) Copyright 2002 Texas Instruments Incorporated. All rights reserved.

*****************************************************************************

** This model is designed as an aid for customers of Texas Instruments.

** TI and its licensors and suppliers make no warranties, either expressed

** or implied, with respect to this model, including the warranties of

** merchantability or fitness for a particular purpose.  The model is

** provided solely on an as is basis.  The entire risk as to its quality

** and performance is with the customer.

*****************************************************************************

* LM393 VOLTAGE COMPARATOR "MACROMODEL" SUBCIRCUIT

* CREATED USING PARTS VERSION 4.03 ON 03/07/90 AT 14:17

* REV (N/A)

* CONNECTIONS:   NON-INVERTING INPUT

*                | INVERTING INPUT

*                | | POSITIVE POWER SUPPLY

*                | | | NEGATIVE POWER SUPPLY

*                | | | | OPEN COLLECTOR OUTPUT

*                | | | | |

.SUBCKT LM393_PWM_V4    1 2 3 4 5

*

  F1    9  3 V1 1

  IEE   3  7 DC 100.0E-6

  VI1  21  1 DC .75

  VI2  22  2 DC .75

  Q1    9 21  7 QIN

  Q2    8 22  7 QIN

  Q3    9  8  4 QMO

  Q4    8  8  4 QMI

.MODEL QIN PNP(IS=800.0E-18 BF=2.000E3)

.MODEL QMI NPN(IS=800.0E-18 BF=1002)

.MODEL QMO NPN(IS=800.0E-18 BF=1000 CJC=1E-15 TR=807.4E-9)

  E1   10  4  9  4  1

  V1   10 11 DC 0

  Q5    5 11  4 QOC

.MODEL QOC NPN(IS=800.0E-18 BF=20.29E3 CJC=1E-15 TF=942.6E-12 TR=543.8E-9)

  DP    4  3 DX

  RP 3  4 46.3E3

.MODEL DX  D(IS=800.0E-18)

*

.ENDS

*## Multisim Component RPU2 ##*
rRPU2 V5 PWM_RAW 2200 vresRPU2
.model vresRPU2 r(  )

*## Multisim Component RVAT ##*
rRVAT PWM_RAW V1 1847.93 vresRVAT
.model vresRVAT r(  )

*## Multisim Component RVAB ##*
rRVAB V1 0 18152.1 vresRVAB
.model vresRVAB r(  )

*## Multisim Component RINPUT ##*
rRINPUT V1 0 1000000 vresRINPUT
.model vresRINPUT r(  )

*## Multisim Component CINPUT ##*
cCINPUT V1 0 1.5e-11
