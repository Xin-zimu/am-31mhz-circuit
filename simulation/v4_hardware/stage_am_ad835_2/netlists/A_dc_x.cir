* Model A (ad835.sub) DC transfer: W vs X, Y=1V, Z=0
.include ../models/third_party_GLuisF/ad835.sub
VX  x1 0 dc 0
VX2 x2 0 dc 0
VY  y1 0 dc 1
VY2 y2 0 dc 0
VZ  z  0 dc 0
VN  vn 0 dc -5
VP  vp 0 dc 5
XU  x1 x2 y1 y2 vn z w vp AD835
RL  w  0 150
.control
dc VX -1.5 1.5 0.01
wrdata ../results/A_dc_x.txt v(w) v(x1) i(VX)
.endc
.end
