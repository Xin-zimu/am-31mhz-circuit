* C3 numerical-consistency run: c4_trap_0p125n_2k_rtol1e5
* Circuit identical to c2_two_load.cir; numerical options only.
*   method=trap maxord=2 reltol=1e-5 trtol=7 tmax=0.125n tstep=0.25n tstop=5m tstart=3m rload=2k
VSUP vcc 0 PWL(0 0 1u 5)
* --- crystal Colpitts (unchanged from C1) ---
R1 vcc b 10k
R2 b 0 10k
Q1 vcc b e 2N3904
R3 e 0 4.7k
C1 b e 33p
C2 e 0 33p
C3 vcc 0 100n
C4 vcc 0 10u
CSTRAY b 0 1p
CX0 b 0 3.0p
VXM b xr 0
RM xr xl 30
LM xl xc 0.002637081993366925
CM xc 0 10.0f
* --- emitter follower buffer (unchanged from C1) ---
CIN e bf 1n
RBT vcc bf 10k
RBB bf 0 10k
QB vcc bf ef 2N3904
REB ef 0 330
COUTB ef bo 1n
* --- common-emitter gain stage (unchanged from C1) ---
CG bo bg 10n
RG1 vcc bg 22k
RG2 bg 0 4.7k
QG cg bg eg 2N3904
RCG vcc cg 1k
REG eg 0 56
COUTG cg out 10n
RLOADG out 0 2k
CLOADG out 0 10p
.model 2N3904   NPN(Is=6.734f Xti=3 Eg=1.11 Vaf=74.03 Bf=416.4 Ne=1.259
+               Ise=6.734f Ikf=66.78m Xtb=1.5 Br=.7371 Nc=2 Isc=0 Ikr=0 Rc=1
+               Cjc=3.638p Mjc=.3085 Vjc=.75 Fc=.5 Cje=4.493p Mje=.2593 Vje=.75
+               Tr=239.5n Tf=301.2p Itf=.4 Vtf=4 Xtf=2 Rb=10)
.options method=trap maxord=2 reltol=1e-5 trtol=7 temp=27 tnom=27

* ===== mod_C_collector =====
V9SRC m9src 0 PULSE(0.0748175 4.07482 200u 20n 20n 4.98u 50u)
* --- collector modulation: modulated rail drives the RF collector load ---
R9T vcc m9b 26700
R9M m9src m9b 68900
R9B m9b 0 20800
Q9D vcc m9b m9rail 2N3904
R9E m9rail 0 1k
C9IN out m9base 1n
R9C vcc m9base 22k
R9F m9base 0 4.7k
Q9M m9rail m9col m9emit 2N3904
R9G m9rail m9col 470
R9H m9emit 0 100
C9OUT m9col amout 10n
R9L amout 0 50
C9L amout 0 10p

.model 2N3904 NPN(Is=6.734f Xti=3 Eg=1.11 Vaf=74.03 Bf=416.4 Ne=1.259
+ Ise=6.734f Ikf=66.78m Xtb=1.5 Br=.7371 Nc=2 Isc=0 Ikr=0 Rc=1
+ Cjc=3.638p Mjc=.3085 Vjc=.75 Fc=.5 Cje=4.493p Mje=.2593 Vje=.75
+ Tr=239.5n Tf=301.2p Itf=.4 Vtf=4 Xtf=2 Rb=10)
.options method=trap maxord=2 reltol=1e-4 trtol=7 temp=27 tnom=27
