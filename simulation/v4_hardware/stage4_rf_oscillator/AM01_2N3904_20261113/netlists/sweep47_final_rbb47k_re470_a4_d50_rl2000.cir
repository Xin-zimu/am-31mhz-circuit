* AM-01 two-2N3904 modulator, RBB=47000, RE=470, RL=2000
VSUP vcc 0 DC 5
CDEC1 vcc 0 100n
CDEC2 vcc 0 10u
VRF src 0 SIN(0 1 31meg)
RIN src rfatt 10000
RSH rfatt 0 100
CIN rfatt b1 1e-10
RB1T vcc b1 10000
RB1B b1 0 10000
Q1 c1 b1 x 2N3904
RC vcc c1 1000
CE1 x 0 1e-09
Q2 x b2 e2 2N3904
RB2T vcc b2 22000
RB2B b2 0 6800
RE e2 0 470
CB2 b2 0 4.7e-11
VMOD mod 0 PULSE(-2 2 2.5e-05 20n 20n 2.496e-05 50u)
CBB mod b2ac 1e-07
RBB b2ac b2 47000
COUT c1 out 1e-10
RL out 0 2000
CL out 0 1e-11
.ic v(vcc)=5 v(src)=0 v(rfatt)=0 v(b1)=2.4631 v(c1)=4.002394 v(x)=1.797899 v(b2)=1.141575 v(e2)=0.4758707 v(mod)=-2 v(b2ac)=-0.862092464832 v(out)=0
.model 2N3904 NPN(Is=6.734f Xti=3 Eg=1.11 Vaf=74.03 Bf=416.4 Ne=1.259
+ Ise=6.734f Ikf=66.78m Xtb=1.5 Br=.7371 Nc=2 Isc=0 Ikr=0 Rc=1
+ Cjc=3.638p Mjc=.3085 Vjc=.75 Fc=.5 Cje=4.493p Mje=.2593 Vje=.75
+ Tr=239.5n Tf=301.2p Itf=.4 Vtf=4 Xtf=2 Rb=10)
.options method=trap maxord=2 reltol=1e-4 trtol=7 temp=27 tnom=27
.control
set num_threads=1
set filetype=binary
op
print v(b1) v(c1) v(x) v(b2) v(e2) @q1[ic] @q2[ic] @q1[ib] @q2[ib]
save v(src) v(rfatt) v(b1) v(c1) v(x) v(b2) v(e2) v(mod) v(b2ac) v(out) i(vsup)
tran 0.5n 130.0u 0 0.5n uic
write D:/实验报告文件夹/电路2/simulation/v4_hardware/stage4_rf_oscillator/AM01_2N3904_20261113/results/raw/sweep47_final_rbb47k_re470_a4_d50_rl2000.raw
quit
.endc
.end
