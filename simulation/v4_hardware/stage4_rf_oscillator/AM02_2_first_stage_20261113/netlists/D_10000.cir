* AM-02.2 candidate D, load=10000
VCC vcc 0 DC 5
R1 vcc b 33k
R2 b 0 10k
Q1 x b e 2N3904
RE1 e 0 470
CE1 e 0 1n
R3 vcc b2 10k
R4 b2 0 10k
CB2 b2 0 100n
Q2 c2 b2 x 2N3904
RC1 vcc c2 1k
COUT c2 out 100p
RL out 0 10000
CL out 0 10p
VTEST vt 0 DC 0 AC 1
CTEST vt b 1
.model 2N3904 NPN(Is=6.734f Xti=3 Eg=1.11 Vaf=74.03 Bf=416.4 Ne=1.259
+ Ise=6.734f Ikf=66.78m Xtb=1.5 Br=.7371 Nc=2 Isc=0 Ikr=0 Rc=1
+ Cjc=3.638p Mjc=.3085 Vjc=.75 Fc=.5 Cje=4.493p Mje=.2593 Vje=.75
+ Tr=239.5n Tf=301.2p Itf=.4 Vtf=4 Xtf=2 Rb=10)
.options method=trap maxord=2 reltol=1e-4 trtol=7 temp=27 tnom=27
.control
set num_threads=1
op
print v(b) v(e) v(b2) v(x) v(c2) i(vcc) @q1[ic] @q1[ib] @q2[ic] @q2[ib]
ac lin 1 31meg 31meg
let zin=-v(b)/i(vtest)
print real(zin) imag(zin) mag(zin) ph(zin)
ac dec 60 1meg 100meg
wrdata D:\实验报告文件夹\电路2\simulation\v4_hardware\stage4_rf_oscillator\AM02_2_first_stage_20261113\results\resp_D_10000.txt frequency db(v(c2)) ph(v(c2))
quit
.endc
.end
