VCC vcc 0 DC 5
R1 vcc b 33k
R2 b 0 6.8k
Q1 c b e 2N3904
RE1 e 0 100
RC1 vcc c 1k
COUT c out 100p

RDC out 0 1G
IAC 0 out AC 1
.model 2N3904 NPN(Is=6.734f Xti=3 Eg=1.11 Vaf=74.03 Bf=416.4 Ne=1.259
+ Ise=6.734f Ikf=66.78m Xtb=1.5 Br=.7371 Nc=2 Isc=0 Ikr=0 Rc=1
+ Cjc=3.638p Mjc=.3085 Vjc=.75 Fc=.5 Cje=4.493p Mje=.2593 Vje=.75
+ Tr=239.5n Tf=301.2p Itf=.4 Vtf=4 Xtf=2 Rb=10)
.options method=trap maxord=2 reltol=1e-4
.control
set num_threads=1
ac lin 1 31meg 31meg
print real(v(out)) imag(v(out)) mag(v(out)) ph(v(out))
quit
.endc
.end
