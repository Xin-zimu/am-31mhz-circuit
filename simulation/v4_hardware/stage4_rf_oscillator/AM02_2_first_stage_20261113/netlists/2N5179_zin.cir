VCC vcc 0 DC 5
R1 vcc b 33k
R2 b 0 6.8k
Q1 c b e 2N5179
RE1 e 0 100
RC1 vcc c 1k
COUT c out 100p
RL out 0 10000
CL out 0 10p

IAC 0 b AC 1
.model 2N5179 NPN(Is=69.28E-18 Xti=3 Eg=1.11 Vaf=100 Bf=282.1 Ne=1.177 Ise=69.28E-18 Ikf=22.03m Xtb=1.5 Br=1.176 Nc=2 Isc=0 Ikr=0 Rc=4 Cjc=1.042p Mjc=.2468 Vjc=.75 Fc=.5 Cje=1.52p Mje=.3223 Vje=.75 Tr=1.588n Tf=135.6p Itf=.27 Vtf=10 Xtf=30 Rb=10)
.options method=trap maxord=2 reltol=1e-4
.control
set num_threads=1
ac lin 1 31meg 31meg
print real(v(b)) imag(v(b)) mag(v(b)) ph(v(b))
quit
.endc
.end
