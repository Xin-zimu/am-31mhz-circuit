* LC-02 total impedance probe | RE=4.7k div=10000/10000 C1=33 C2=33 L=1280.07nH Q=60 SRF=200
VSUP vcc 0 5
R1 vcc b 10000
R2 b 0 10000
Q1 vcc b e 2N3904
R3 e 0 4.7k
C1 b e 33p
C2 e 0 33p
CT e 0 0.5p
CBLK b nL 1000p
LR nL n1 4.155507
L1 n1 0 1280.07n
CP n1 0 0.000000000
C3 vcc 0 100n
C4 vcc 0 10u
IAC nL 0 ac 1
.model 2N3904   NPN(Is=6.734f Xti=3 Eg=1.11 Vaf=74.03 Bf=416.4 Ne=1.259
+               Ise=6.734f Ikf=66.78m Xtb=1.5 Br=.7371 Nc=2 Isc=0 Ikr=0 Rc=1
+               Cjc=3.638p Mjc=.3085 Vjc=.75 Fc=.5 Cje=4.493p Mje=.2593 Vje=.75
+               Tr=239.5n Tf=301.2p Itf=.4 Vtf=4 Xtf=2 Rb=10)
.options method=trap maxord=2 reltol=1e-3 trtol=7 temp=27 tnom=27
.control
set filetype=binary
ac dec 2000 20meg 45meg
write t_orig.raw v(nL)
quit
.endc
.end
