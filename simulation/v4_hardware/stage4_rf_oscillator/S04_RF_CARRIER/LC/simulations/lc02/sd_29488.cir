* seeded self-excitation test | seed 1.0V on nL
VSUP vcc 0 PWL(0 0 1u 5)
R1 vcc b 10000
R2 b 0 10000
Q1 vcc b e 2N3904
R3 e 0 220
C1 b e 33p
C2 e 0 33p
CT e 0 0.5p
CBLK b nL 1000p
LR nL n1 4.155507
L1 n1 0 1280.07n
CP n1 0 0.000000000
C3 vcc 0 100n
C4 vcc 0 10u
COUT e out 1n
RLOAD out 0 2000
CLOAD out 0 10p
.model 2N3904   NPN(Is=6.734f Xti=3 Eg=1.11 Vaf=74.03 Bf=416.4 Ne=1.259
+               Ise=6.734f Ikf=66.78m Xtb=1.5 Br=.7371 Nc=2 Isc=0 Ikr=0 Rc=1
+               Cjc=3.638p Mjc=.3085 Vjc=.75 Fc=.5 Cje=4.493p Mje=.2593 Vje=.75
+               Tr=239.5n Tf=301.2p Itf=.4 Vtf=4 Xtf=2 Rb=10)
.options method=trap maxord=2 reltol=1e-3 trtol=7 temp=27 tnom=27
.ic v(nL)=1.0
.control
set filetype=binary
set num_threads=1
save v(vcc) v(b) v(e) v(out) v(nL) i(vsup)
tran 0.25n 600u 0 0.25n uic
write sd_29488.raw
quit
.endc
.end
