* Device-level LC Colpitts 31 MHz | L=1200nH Q=60 SRF=200MHz | trimmer CT=32.5pF
* Rs=3.8956 ohm, Cp=0.5277 pF | C1=C2=32.1pF | 5V | UIC
VSUP vcc 0 PWL(0 0 1u 5)
R1 vcc b 10k
R2 b 0 10k
Q1 vcc b e 2N3904
R3 e 0 4.7k
C1 b e 32.1p
C2 e 0 32.1p
CT e 0 32.5p
CBLK b nL 1000p
LR nL n1 3.895575
L1 n1 0 1200n
CP n1 0 0.527714p
C3 vcc 0 100n
C4 vcc 0 10u
CIN e bf 1n
RBT vcc bf 10k
RBB bf 0 10k
QB vcc bf ef 2N3904
REB ef 0 330
COUT ef out 1n
RLOAD out 0 2000
CLOAD out 0 10p
RLK out 0 1e15
.model 2N3904   NPN(Is=6.734f Xti=3 Eg=1.11 Vaf=74.03 Bf=416.4 Ne=1.259
+               Ise=6.734f Ikf=66.78m Xtb=1.5 Br=.7371 Nc=2 Isc=0 Ikr=0 Rc=1
+               Cjc=3.638p Mjc=.3085 Vjc=.75 Fc=.5 Cje=4.493p Mje=.2593 Vje=.75
+               Tr=239.5n Tf=301.2p Itf=.4 Vtf=4 Xtf=2 Rb=10)
.options method=trap maxord=2 reltol=1e-3 trtol=7 temp=27 tnom=27
.control
set filetype=binary
set num_threads=1
save v(vcc) v(b) v(e) v(out) i(vsup)
tran 0.125n 1000u 90u 0.125n uic
write settle_1000us.raw
quit
.endc
.end
