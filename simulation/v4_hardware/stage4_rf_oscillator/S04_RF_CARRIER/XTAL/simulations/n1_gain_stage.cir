* N1 31 MHz gain stage - CORRECTED netlist
* commit 9338b76 shipped a broken netlist; this file replaces it.
* Provenance: topology of the actually-run file ft68.cir
*   sha256 0009e9e9e084d30f8c3eb04d1a2b5f830c21b49a093b8b00b943976663278f82
*   which did reproduce 2.0413 Vpp. This is that topology, self-contained.
* Audit report: ../reports/  (CJK filename, see README of S04_RF_CARRIER)
*
* TOPOLOGY AS ACTUALLY SIMULATED (RE1 only; RE2/CE were floating and inert,
* proven by deleting them: output identical to 8 decimal places)
*   common emitter, collector -> RC -> VCC, output taken at the collector
*   RE1 = 68 ohm UNBYPASSED  (there is no second emitter resistor in the path)
*   bias 22k / 4.7k, VCC = 5 V, load 2 kOhm || 10 pF
*
* THIS DESIGN POINT DOES NOT MEET SPEC. Known defects, not hidden:
*   - Zin ~318 ohm at 31 MHz; S04-01 requires >= 100 kOhm        [FAIL]
*   - at the measured 0.415 Vpp buffer output: 1.6706 Vpp        [FAIL]
*   - 10 kOhm load: 2.1872 Vpp, above the 2.1 Vpp ceiling        [FAIL]
*   - input amplitude 0.530 Vpp is an ASSUMPTION, not measured
*
* Input: 0.265 Vpk (0.530 Vpp)
VSUP vcc 0 5
VIN in 0 SIN(0 0.265 31meg)
R1 vcc b 22k
R2 b 0 4.7k
Q1 c b e 2N3904
RC vcc c 1k
RE1 e 0 68
CIN in b 10n
COUT c out 10n
RLOAD out 0 2k
CLOAD out 0 10p
* UNCG educational 2N3904 model - NOT the delivered transistor lot
.model 2N3904   NPN(Is=6.734f Xti=3 Eg=1.11 Vaf=74.03 Bf=416.4 Ne=1.259
+               Ise=6.734f Ikf=66.78m Xtb=1.5 Br=.7371 Nc=2 Isc=0 Ikr=0 Rc=1
+               Cjc=3.638p Mjc=.3085 Vjc=.75 Fc=.5 Cje=4.493p Mje=.2593 Vje=.75
+               Tr=239.5n Tf=301.2p Itf=.4 Vtf=4 Xtf=2 Rb=10)
.options method=gear maxord=2 reltol=1e-3 trtol=7 temp=27 tnom=27
.control
set filetype=binary
set num_threads=1
tran 0.0625n 50u 0 0.0625n
write n1_gain_stage.raw v(out) v(c) v(vcc) i(vsup)
quit
.endc
.end
