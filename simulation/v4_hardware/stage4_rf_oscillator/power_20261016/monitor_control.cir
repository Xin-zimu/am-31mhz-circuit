* Current monitor polarity and scale control
VV5 V5 0 5
RTEST V5 0 1k
HMON IMON 0 VV5 -1
.end
