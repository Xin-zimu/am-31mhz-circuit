* S1 EF+CE RFC 50 ohm
VCC vcc 0 DC 5
R01 vcc b0 100k
R02 b0 0 100k
Q0 vcc b0 e0 2N3904
RE0 e0 0 470
C01 e0 b1 1n
R11 vcc b1 3.3k
R12 b1 0 680
Q1 c b1 e1 2N3904
RE1 e1 0 3
LRFC vcc c 1uH
COUT c out 100p
RL out 0 50
CL out 0 10p
VIN vt 0 DC 0 AC 1
CIN vt b0 1n
.model 2N3904 NPN(Is=6.734f Xti=3 Eg=1.11 Vaf=74.03 Bf=416.4 Ne=1.259 Ise=6.734f Ikf=66.78m Xtb=1.5 Br=.7371 Nc=2 Isc=0 Ikr=0 Rc=1 Cjc=3.638p Mjc=.3085 Vjc=.75 Fc=.5 Cje=4.493p Mje=.2593 Vje=.75 Tr=239.5n Tf=301.2p Itf=.4 Vtf=4 Xtf=2 Rb=10)
.options method=trap maxord=2 reltol=1e-4
.control
set num_threads=1
op
print v(b0) v(e0) v(b1) v(e1) v(c) @q0[ic] @q1[ic] @q1[ib] i(vcc)
ac lin 1 31meg 31meg
print v(b0) v(e0) v(b1) v(e1) v(c) v(out)
wrdata s1_test.txt frequency db(v(out)) ph(v(out))
quit
.endc
.end
