* AM-01 (frozen) + AM-02.3 stage S1, 4 Vpp, duty 0.50
VSUP vcc 0 DC 5
CDEC1 vcc 0 100n
CDEC2 vcc 0 10u
VRF src 0 SIN(0 1 31meg)
RIN src rfatt 2200
RSH rfatt 0 10
CIN rfatt b1 1n
RB1T vcc b1 10k
RB1B b1 0 10k
Q1 c1 b1 x 2N3904
RC vcc c1 1k
CE1 x 0 1n
Q2 x b2 e2 2N3904
RB2T vcc b2 22k
RB2B b2 0 6.8k
RE e2 0 1.2k
CB2 b2 0 47p
CBB mod b2ac 100n
RBB b2ac b2 62k
COUT c1 out 100p
CL out 0 1e-11
* --- AM-02.3 stage S1: CE + RFC + emitter follower (broadband, untuned)
CIN2 out ba 1e-07
RBAT vcc ba 22000
RBAB ba 0 4700
QA ca ba ea 2N3904
REA ea 0 10
LRFC vcc ca 2.2e-06
QB vcc ca eb 2N3904
REB eb 0 180
COUT2 eb rl 1e-07
RLD rl 0 50
CLD rl 0 1e-11
VMOD mod 0 PULSE(-2 2 2.5e-05 20n 20n 2.496e-05 50u)

.model 2N3904 NPN(Is=6.734f Xti=3 Eg=1.11 Vaf=74.03 Bf=416.4 Ne=1.259
+ Ise=6.734f Ikf=66.78m Xtb=1.5 Br=.7371 Nc=2 Isc=0 Ikr=0 Rc=1
+ Cjc=3.638p Mjc=.3085 Vjc=.75 Fc=.5 Cje=4.493p Mje=.2593 Vje=.75
+ Tr=239.5n Tf=301.2p Itf=.4 Vtf=4 Xtf=2 Rb=10)
.options method=trap maxord=2 reltol=1e-4 trtol=7 temp=27 tnom=27
.control
set num_threads=1
set filetype=binary
op
write probe_S1.raw
quit
.endc
.end
