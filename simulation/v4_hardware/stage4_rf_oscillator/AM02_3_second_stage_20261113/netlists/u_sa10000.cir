* AM-01 (frozen) + AM-02.3 stage SA, 4 Vpp, duty 0.50
VSUP vcc 0 DC 5
CDEC1 vcc 0 100n
CDEC2 vcc 0 10u
VRF src 0 SIN(0 1 31meg)
RIN src rfatt 2200
RSH rfatt 0 10
CIN rfatt b1 1n
RB1T vcc b1 10k
RB1B b1 0 10k
Q1 c1 b1 x 2N3904
RC vcc c1 1k
CE1 x 0 1n
Q2 x b2 e2 2N3904
RB2T vcc b2 22k
RB2B b2 0 6.8k
RE e2 0 1.2k
CB2 b2 0 47p
CBB mod b2ac 100n
RBB b2ac b2 62k
COUT c1 out 100p
* CL at AM-01 "out" is NOT added in the cascade: the second stage is the load
* there, exactly as AM-02.2 did it. The 10 pF interface load belongs to the
* stand-alone TP2 termination, not to a loaded cascade node.
* --- AM-02.2 scheme A (frozen) + measurement load
VJ out ba_a DC 0   $ DC-coupled junction, as AM-02.2 froze it
R1 vcc ba_a 33k
R2 ba_a 0 6.8k
QAA ca_a ba_a ea_a 2N3904
RE1 ea_a 0 100
RC1 vcc ca_a 1k
COUTA ca_a rl 1e-10
RLD rl 0 10000
CLD rl 0 1e-11
VMOD mod 0 PULSE(-2 2 2.5e-05 20n 20n 2.496e-05 50u)
.ic v(vcc)=5 v(src)=0 v(rfatt)=0 v(b1)=2.482471883 v(c1)=4.574986496
+ v(x)=1.839783667 v(b2)=1.161919273 v(e2)=0.5185282249 v(mod)=-2 v(b2ac)=-0.8409366279
+ v(out)=0.8026162077 v(ba_a)=0.8026162077 v(ea_a)=0.1309075589 v(ca_a)=3.70008606 v(rl)=0
.model 2N3904 NPN(Is=6.734f Xti=3 Eg=1.11 Vaf=74.03 Bf=416.4 Ne=1.259
+ Ise=6.734f Ikf=66.78m Xtb=1.5 Br=.7371 Nc=2 Isc=0 Ikr=0 Rc=1
+ Cjc=3.638p Mjc=.3085 Vjc=.75 Fc=.5 Cje=4.493p Mje=.2593 Vje=.75
+ Tr=239.5n Tf=301.2p Itf=.4 Vtf=4 Xtf=2 Rb=10)
.options method=trap maxord=2 reltol=1e-4 trtol=7 temp=27 tnom=27
.control
set num_threads=1
set filetype=binary
op
save v(out) v(rl) v(b2) v(b2ac) v(c1) v(x) v(e2) v(mod) i(vsup) v(ba_a) v(ea_a) v(ca_a) v(rl)
tran 0.5n 128.0u 0 0.5n uic
write u_sa10000.raw
quit
.endc
.end
