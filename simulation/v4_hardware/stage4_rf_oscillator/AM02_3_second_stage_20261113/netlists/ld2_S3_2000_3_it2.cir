* AM-01 (frozen) + AM-02.3 stage S3, 3 Vpp, duty 0.50
VSUP vcc 0 DC 5
CDEC1 vcc 0 100n
CDEC2 vcc 0 10u
VRF src 0 SIN(0 1 31meg)
RIN src rfatt 2200
RSH rfatt 0 10
CIN rfatt b1 1n
RB1T vcc b1 10k
RB1B b1 0 10k
Q1 c1 b1 x 2N3904
RC vcc c1 1k
CE1 x 0 1n
Q2 x b2 e2 2N3904
RB2T vcc b2 22k
RB2B b2 0 6.8k
RE e2 0 1.2k
CB2 b2 0 47p
CBB mod b2ac 100n
RBB b2ac b2 62k
COUT c1 out 100p
* AM-01 "out" carries no DC path of its own (COUT blocks it). A capacitively
* coupled second stage must therefore supply one, otherwise the operating
* point of that node is undefined and ngspice reports a singular matrix.
RLK out 0 10k   $ interface DC return
* --- S3: CE + RFC collector load + emitter-follower output (untuned)
CIN2 out ba 1e-07
RBAT vcc ba 2700
RBAB ba 0 1100
QA ca ba ea 2N3904
RAX ea ex 2
REA ex 0 100
CEA ex 0 1e-09
LRFC vcc ca 2.2e-06
QB vcc ca eb 2N3904
REB eb 0 180
COUT2 eb rl 1e-07
RLD rl 0 2000
CLD rl 0 1e-11
VMOD mod 0 PULSE(-1.5 1.5 2.5e-05 20n 20n 2.496e-05 50u)
.ic v(vcc)=5 v(src)=0 v(rfatt)=0 v(b1)=2.482471883 v(c1)=4.574986496
+ v(x)=1.839783667 v(b2)=1.161919273 v(e2)=0.5185282249 v(mod)=-2 v(b2ac)=-0.6739293317
+ v(out)=0 v(ba)=1.415276377 v(ea)=0.6987247148 v(ex)=0.6850242302 v(ca)=5
+ v(eb)=4.243756503 v(rl)=0
.model 2N3904 NPN(Is=6.734f Xti=3 Eg=1.11 Vaf=74.03 Bf=416.4 Ne=1.259
+ Ise=6.734f Ikf=66.78m Xtb=1.5 Br=.7371 Nc=2 Isc=0 Ikr=0 Rc=1
+ Cjc=3.638p Mjc=.3085 Vjc=.75 Fc=.5 Cje=4.493p Mje=.2593 Vje=.75
+ Tr=239.5n Tf=301.2p Itf=.4 Vtf=4 Xtf=2 Rb=10)
.options method=trap maxord=2 reltol=1e-4 trtol=7 temp=27 tnom=27
.control
set num_threads=1
set filetype=binary
op
save v(out) v(rl) v(b2) v(b2ac) v(c1) v(x) v(e2) v(mod) i(vsup) v(ba) v(ea) v(ex) v(ca) v(eb) v(rl)
tran 0.5n 45.0u 0 0.5n uic
write ld2_S3_2000_3_it2.raw
quit
.endc
.end
