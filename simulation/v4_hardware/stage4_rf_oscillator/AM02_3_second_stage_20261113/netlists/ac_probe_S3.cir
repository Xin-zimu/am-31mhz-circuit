* AM-02.3 stage S3 standalone
VCCX vcc 0 DC 5
VS in0 0 DC 0 AC 1
* --- S3: CE + RFC collector load + emitter-follower output (untuned)
CIN2 in0 ba 1e-07
RBAT vcc ba 2700
RBAB ba 0 1100
QA ca ba ea 2N3904
RAX ea ex 2
REA ex 0 100
CEA ex 0 1e-09
LRFC vcc ca 2.2e-06
QB vcc ca eb 2N3904
REB eb 0 180
COUT2 eb rl 1e-07
RLD rl 0 50
CLD rl 0 1e-11
.model 2N3904 NPN(Is=6.734f Xti=3 Eg=1.11 Vaf=74.03 Bf=416.4 Ne=1.259
+ Ise=6.734f Ikf=66.78m Xtb=1.5 Br=.7371 Nc=2 Isc=0 Ikr=0 Rc=1
+ Cjc=3.638p Mjc=.3085 Vjc=.75 Fc=.5 Cje=4.493p Mje=.2593 Vje=.75
+ Tr=239.5n Tf=301.2p Itf=.4 Vtf=4 Xtf=2 Rb=10)
.options method=trap maxord=2 reltol=1e-4 trtol=7 temp=27 tnom=27
.control
set num_threads=1
set filetype=binary
op
print v(ca) v(ea) @qa[ic] @qa[ib] i(vccx)
ac dec 80 5meg 120meg
write ac_probe_S3.raw
quit
.endc
.end
