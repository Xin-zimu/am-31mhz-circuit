* Exploratory 5 V Colpitts; C518062 motional parameters NOT verified
* Independent DUT; no RF generator, buffer, modulator or main project
* BFR93A model port order C B E, not physical package pin numbering
* Assumed Cm=10 fF, C0=3 pF, Rm=30 ohm
* fL=31 MHz at CL=18 pF, fs=30992621.6826 Hz
VSUP vcc 0 PWL(0 0 1u 5)
HISUP isupply 0 VSUP -1
RBUP vcc base 10k
RBDN base 0 10k
XQ vcc base emit BFR93A
RE emit 0 4700.0
CF base emit 33p
CE emit 0 33p
CPAR base 0 1p
* High impedance observation only; no buffer or 2k/10pF load
RPROBE emit 0 100meg
CX0 base 0 3p
VXM base xr 0
RXM xr xl 30
LXM xl xc 0.00263708199336692
CXM xc 0 10f
HIMOT imotional 0 VXM 1
* Filename:  BFR93A_SPICE.PRM
* BFR93A SPICE MODEL
* PHILIPS SEMICONDUCTORS
* Date : September 1995
*
* PACKAGE : SOT23 DIE MODEL : BFR91A
* 1: COLLECTOR; 2: BASE; 3: EMITTER;
.SUBCKT BFR93A 1 2 3
Q1 6 5 7 7 BFR91A
* SOT23 parasitic model
               Lb  4 5 .4n
               Le  7 8 .83n
               L1  2 4 .35n
               L2  1 6 .17n
               L3  3 8 .35n
              Ccb  4 6 71f
              Cbe  4 8 2f
              Cce  6 8 71f
*
* PHILIPS SEMICONDUCTORS                                     Version:   1.0
* Filename:   BFR91A.PRM                                     Date: Feb 1992
*
.MODEL  BFR91A   NPN
+              IS = 1.32873E-015
+              BF = 1.02000E+002
+              NF = 1.00025E+000
+             VAF = 5.19033E+001
+             IKF = 8.15511E+000
+             ISE = 1.39029E-014
+              NE = 1.51292E+000
+              BR = 1.76953E+001
+              NR = 9.94038E-001
+             VAR = 3.28032E+000
+             IKR = 1.00000E+001
+             ISC = 1.04297E-015
+              NC = 1.18993E+000
+              RB = 1.00000E+001
+             IRB = 1.00000E-006
+             RBM = 1.00000E+001
+              RE = 7.63636E-001
+              RC = 9.00000E+000
+              EG = 1.11000E+000
+             XTI = 3.00000E+000
+             CJE = 2.03216E-012
+             VJE = 6.00000E-001
+             MJE = 2.90076E-001
+              TF = 6.55790E-012
+             XTF = 3.89752E+001
+             VTF = 1.09308E+001
+             ITF = 5.21078E-001
+             CJC = 1.00353E-012
+             VJC = 3.40808E-001
+             MJC = 1.94223E-001
.ENDS
.options method=trap maxord=2 reltol=0.001 trtol=7 temp=27 tnom=27
.control
set filetype=binary
set num_threads=1
save v(vcc) v(base) v(emit) v(isupply) v(imotional)
tran 0.0625n 2000.0u 1900.0u 0.0625n uic
write D:/ms_xsp/s04_crosscheck_20261017/ng_2ms_00625ns.raw
quit
.endc
.end
