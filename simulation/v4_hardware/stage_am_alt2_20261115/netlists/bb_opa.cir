* ALT2 baseband and DC transistor load; no RF or wireless claim
.model 2N3904   NPN(Is=6.734f Xti=3 Eg=1.11 Vaf=74.03 Bf=416.4 Ne=1.259
+               Ise=6.734f Ikf=66.78m Xtb=1.5 Br=.7371 Nc=2 Isc=0 Ikr=0 Rc=1
+               Cjc=3.638p Mjc=.3085 Vjc=.75 Fc=.5 Cje=4.493p Mje=.2593 Vje=.75
+               Tr=239.5n Tf=301.2p Itf=.4 Vtf=4 Xtf=2 Rb=10)

VSUP vcc 0 5
* TI LM393 macromodel from installed NI Multisim master database LM393/TI.
* U1A: DIP pins IN+=3 IN-=2 V+=8 GND=4 OUT=1
* U1B: DIP pins IN+=5 IN-=6 V+=8 GND=4 OUT=7
V5 V5 0 5
CDEC V5 0 100n
CBULK V5 0 10u
RPU1 V5 OSC 2.2k
RHT V5 HYST 30k
RHB HYST 0 10k
RHF OSC HYST 20k
RFIX OSC FSET 22k
RVRF FSET RAMP 15288.86443
CT RAMP 0 1n
XU1A HYST RAMP V5 0 OSC LM393_TI
* VDUTY resistor chain: 10k + 10k potentiometer + 4.7k.
RDT V5 DUTY_TOP 10k
RVDT DUTY_TOP DUTY 7362.468268
RVDB DUTY DUTY_BOT 2637.531732
RDB DUTY_BOT 0 4.7k
XU1B DUTY RAMP V5 0 PWM_RAW LM393_TI
RPU2 V5 PWM_RAW 2200
* 20k amplitude potentiometer, wiper at V1, includes specified load.
RVAT PWM_RAW V1 1847.9278199999999
RVAB V1 0 18152.07218
RINPUT V1 0 1000000
CINPUT V1 0 15p
*****************************************************************************

* (C) Copyright 2002 Texas Instruments Incorporated. All rights reserved.

*****************************************************************************

** This model is designed as an aid for customers of Texas Instruments.

** TI and its licensors and suppliers make no warranties, either expressed

** or implied, with respect to this model, including the warranties of

** merchantability or fitness for a particular purpose.  The model is

** provided solely on an as is basis.  The entire risk as to its quality

** and performance is with the customer.

*****************************************************************************

* LM393 VOLTAGE COMPARATOR "MACROMODEL" SUBCIRCUIT

* CREATED USING PARTS VERSION 4.03 ON 03/07/90 AT 14:17

* REV (N/A)

* CONNECTIONS:   NON-INVERTING INPUT

*                | INVERTING INPUT

*                | | POSITIVE POWER SUPPLY

*                | | | NEGATIVE POWER SUPPLY

*                | | | | OPEN COLLECTOR OUTPUT

*                | | | | |

.SUBCKT LM393_TI    1 2 3 4 5

*

  F1    9  3 V1 1

  IEE   3  7 DC 100.0E-6

  VI1  21  1 DC .75

  VI2  22  2 DC .75

  Q1    9 21  7 QIN

  Q2    8 22  7 QIN

  Q3    9  8  4 QMO

  Q4    8  8  4 QMI

.MODEL QIN PNP(IS=800.0E-18 BF=2.000E3)

.MODEL QMI NPN(IS=800.0E-18 BF=1002)

.MODEL QMO NPN(IS=800.0E-18 BF=1000 CJC=1E-15 TR=807.4E-9)

  E1   10  4  9  4  1

  V1   10 11 DC 0

  Q5    5 11  4 QOC

.MODEL QOC NPN(IS=800.0E-18 BF=20.29E3 CJC=1E-15 TF=942.6E-12 TR=543.8E-9)

  DP    4  3 DX

  RP 3  4 46.3E3

.MODEL DX  D(IS=800.0E-18)

*

.ENDS

.include ../sources/OPA197_multisim.lib
XBB V1 vm V5 0 vm OPA197_TI

RMT vcc mb 15000
RMB mb 0 3300
RMINJ vm mb 47000
QM mc mb me 2N3904
RMC vcc mc 1000
RME me 0 470
CME me 0 1e-09

.options method=trap maxord=2 reltol=1e-5 trtol=7 temp=27 tnom=27
.control
set filetype=binary
set num_threads=1
save v(v1) v(vm) v(pwm_raw) v(mb) v(mc) v(me) i(v5) i(vsup)
tran 20n 1.5m 1.2m 20n uic
write bb_opa.raw
quit
.endc
.end
