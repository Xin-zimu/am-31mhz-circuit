RF Colpitts oscillator - 2N3904 surrogate model
.param CFIX=68p CTRIM=17.5p
* Q1-Q2 from user V1.1, isolated oscillator test
VTX VCC_TX 0 9
R13 VCC_TX VCC_OSC 22
C10 VCC_OSC 0 100n
C11 VCC_OSC 0 1n
Q1 OSC_C OSC_B OSC_E Q3904
R14 VCC_OSC OSC_B 47k
R15 OSC_B 0 15k
C12 OSC_B 0 1n
R16 OSC_E 0 330
C13 OSC_E 0 180p
L1 VCC_OSC OSC_L 470n
RL1 OSC_L OSC_C 1
C14 OSC_C OSC_E {CFIX}
CT1 OSC_C OSC_E {CTRIM}
C15 OSC_C TP2 2.2p
R17 TP2 0 100k
C16 OSC_C Q2_B 4.7p
R18 VCC_OSC Q2_B 39k
R19 Q2_B 0 15k
Q2 VCC_OSC Q2_B Q2_E Q3904
R20 Q2_E 0 470
C17 Q2_E CARRIER_BUF 22p
RLOAD CARRIER_BUF 0 100k
* 1mV initial perturbation starts oscillation; no carrier source
.ic V(OSC_C)=8.901
.model Q3904 NPN(IS=1E-14 VAF=100
+ BF=300 IKF=0.4 XTB=1.5 BR=4
+ CJC=4E-12 CJE=8E-12 RB=20 RC=0.1 RE=0.1
+ TR=250E-9 TF=350E-12 ITF=1 VTF=2 XTF=3)
.options plotwinsize=0 reltol=0.0003
.tran 0 30u 0 0.3n uic
.meas TRAN OSC_PP PP V(OSC_C) FROM=25u TO=30u
.meas TRAN BUF_PP PP V(CARRIER_BUF) FROM=25u TO=30u
.meas TRAN TX_CURRENT AVG -I(VTX) FROM=25u TO=30u
.meas TRAN PERIOD TRIG V(OSC_C) VAL=8 RISE=1 TD=25u TARG V(OSC_C) VAL=8 RISE=101 TD=25u
.meas TRAN FREQ PARAM 100/PERIOD
.save V(OSC_C) V(CARRIER_BUF) V(VCC_OSC) I(VTX)
.end
