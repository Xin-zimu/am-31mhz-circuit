LF oscillator CORRECTED
* Nodes: TRI=TP_TRI, V1=TP1. Rfreq includes R6+VR1.
* OP18 and COMP_OC are educational approximations, not vendor models.
VCC VCC 0 9
VREF VREF 0 4.5
VDUTY VDUTY 0 5.69603725
R3 VCC SQ_OSC 2.2k
R4 SQ_OSC HYST 30k
R5 TRI HYST 10k
XU1A HYST VREF SQ_OSC VCC 0 COMP_OC
RFREQ SQ_OSC INT_N 33945.0729
C8 TRI INT_N 1n
R7 TRI INT_N 1meg
XU2A VREF INT_N TRI VCC 0 OP18
XU1B TRI VDUTY PWM_RAW VCC 0 COMP_OC
R10 VCC PWM_RAW 2.2k
R11 PWM_RAW AMP_TOP 5.6k
RVR3A AMP_TOP V1_PRE 7861.93671
RVR3B V1_PRE 0 2138.06329
R12 V1_PRE V1 1k
* AC-equivalent modulation load: R23 + (R21 || R22) ~ 44.8k.
* This fixed resistance does not reproduce the Q3 nonlinear bias or C19 DC block.
RACLOAD V1 0 44.8k
RLOAD V1 0 1meg

.subckt COMP_OC P N OUT VP VN
ECP CI VN N P 1
RCOMP CI CD 1k
CCOMP CD VN 100p
SCOMP OUT VN CD VN SWOC
.ends COMP_OC
.model SWOC SW(Ron=25 Roff=1e10 Vt=0 Vh=0.001)
.subckt OP18 P N OUT VP VN
EGAIN A VN P N 100000
RDOM A B 1k
CDOM B VN 884.2n
BBUF C VN V=limit(V(B,VN),0.05,V(VP,VN)-0.05)
ROUT C OUT 50
.ends OP18

.ic V(TRI)=4.6 V(INT_N)=4.5
.options plotwinsize=0 reltol=0.0005
.save V(TRI) V(SQ_OSC) V(PWM_RAW) V(V1) V(VDUTY)
.tran 100n 1.2m 0 100n uic
.end
