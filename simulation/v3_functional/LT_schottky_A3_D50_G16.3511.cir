* 31MHz AM SYSTEM - XSPICE variant of the original .cir (no LTspice-isms)
VCC VCC 0 9
VREF VREF 0 4.5
VINPUT V1 0 PULSE(0 3 10u 20n 20n 25u 50u)
VCARRIER TP2 0 SIN(0 1.000001953296563 31meg)
EAM TP3 0 POLY(2) (TP2,0) (V1,0) 0 0.6 0 0 0.1
EPA TP4 0 TP3 0 1
ECHANNEL ANT_RX 0 TP4 0 0.1
ERX TP5 0 ANT_RX 0 10
RRF TP5 RF_OUT 50
C110 RF_OUT DET_RF 220p
R117 DET_RF 0 1k
D101 DET_RF TP6 SCHOTTKY_EST
R110 TP6 0 10k
C111 TP6 0 47p
C115 TP6 BB_IN 10n
R113 BB_IN VREF 100k
EBB AMP_IDEAL VREF BB_IN VREF 16.3511
RBB AMP_IDEAL V2_OP 1k
CBB V2_OP 0 1.32629119243e-10
R116 V2_OP V2 100
RLOAD V2 0 1meg
.model SCHOTTKY_EST D(Is=20n N=1.06 Rs=2 Cjo=2p M=0.33 Vj=0.35 Bv=70 Ibv=10u)
.options plotwinsize=0 reltol=0.001
.save V(V1) V(V2) V(TP6) V(TP3) V(TP2)
.tran 2n 5m 4.8m 2n
.end
